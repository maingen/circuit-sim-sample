* Ported legal reference for agc_controller_tl_run_01
.subckt AGC_CMOS_OPAMP inp inn out vcc
R_AGC_OP_NB vcc agc_op_nbias 35k
M_AGC_OP_NB agc_op_nbias agc_op_nbias 0 0 NMOS_SYS W=10u L=1u
M_AGC_OP_TAIL agc_op_etail agc_op_nbias 0 0 NMOS_SYS W=20u L=1u
M_AGC_OP_INP agc_op_nleft inp agc_op_etail 0 NMOS_SYS W=40u L=1u
M_AGC_OP_INN agc_op_nfirst inn agc_op_etail 0 NMOS_SYS W=40u L=1u
M_AGC_OP_PLOADD agc_op_nleft agc_op_nleft vcc vcc PMOS_SYS W=20u L=1u
M_AGC_OP_PLOADM agc_op_nfirst agc_op_nleft vcc vcc PMOS_SYS W=20u L=1u
M_AGC_OP_PVAS out agc_op_nfirst vcc vcc PMOS_SYS W=80u L=1u
M_AGC_OP_NVAS out agc_op_nbias 0 0 NMOS_SYS W=40u L=1u
C_AGC_OP_COMP agc_op_nfirst out 2p
C_AGC_OP_OUT out 0 1p
.ends AGC_CMOS_OPAMP
.subckt candidate detp detn oa pkd agc agc_pkd_ref agc_ref vcc vss
R_AGC_LP_P detp agc_lp_p 600
R_AGC_LP_N detn agc_lp_n 600
C_AGC_LP agc_lp_p agc_lp_n 150f
R_AGC_SF_REF vcc agc_sfbias 4.2k
Q_AGC_SF_REF agc_sfbias agc_sfbias 0 QN_SYS area=1
Q_AGC_SF_P_SINK agc_sf_p agc_sfbias 0 QN_SYS area=1
Q_AGC_SF_N_SINK agc_sf_n agc_sfbias 0 QN_SYS area=1
Q_AGC_SF_P vcc agc_lp_p agc_sf_p QN_SYS area=2
Q_AGC_SF_N vcc agc_lp_n agc_sf_n QN_SYS area=2
R_AGC_PP agc_sf_p agc_op4p 40k
R_AGC_PV agc_pkd_ref agc_op4p 560k
R_AGC_IN agc_sf_n agc_op4n 40k
R_AGC_FB pkd agc_op4n 560k
X_AGC_OP4 agc_op4n agc_op4p pkd vcc AGC_CMOS_OPAMP
X_AGC_OP5 pkd oa agc_op5_raw vcc AGC_CMOS_OPAMP
R_AGC_OP agc_op5_raw agc 100k
R_AGC_GC_REF agc agc_ref 6.45k
C_AGC_OUT agc 0 10p
.ends candidate
