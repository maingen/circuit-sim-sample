* Replace this starter with the complete flattened sample 3 transceiver.
.end
