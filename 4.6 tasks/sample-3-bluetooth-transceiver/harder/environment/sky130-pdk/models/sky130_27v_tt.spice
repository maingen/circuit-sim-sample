* Minimal SKY130A typical-corner include set for 2.7 V tolerant MOS devices.
* Open PDKs revision: c6d73a35f524070e85faff4a6a9eef49553ebc2b
.option scale=1u
.param mc_mm_switch=0
.param mc_pr_switch=0
.param sky130_fd_pr__nfet_g5v0d10v5__dlc_rotweak=0
.param sky130_fd_pr__pfet_g5v0d10v5__dlc_rotweak=0
.include "models/sky130A/libs.tech/ngspice/parameters/lod.spice"
.include "models/sky130A/libs.tech/ngspice/corners/tt/nonfet.spice"
.include "models/sky130A/libs.ref/sky130_fd_pr/spice/sky130_fd_pr__nfet_g5v0d10v5__tt.pm3.spice"
.include "models/sky130A/libs.ref/sky130_fd_pr/spice/sky130_fd_pr__pfet_g5v0d10v5__tt.pm3.spice"
.include "models/sky130A/libs.ref/sky130_fd_pr/spice/sky130_fd_pr__nfet_g5v0d10v5__mismatch.corner.spice"
.include "models/sky130A/libs.ref/sky130_fd_pr/spice/sky130_fd_pr__pfet_g5v0d10v5__mismatch.corner.spice"
.include "models/sky130A/libs.ref/sky130_fd_pr/spice/sky130_fd_pr__pnp_05v5_W0p68L0p68.model.spice"
