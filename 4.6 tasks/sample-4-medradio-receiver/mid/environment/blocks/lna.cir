* Flattened lna block starter.
.include "/opt/pdk/sky130_tt.inc"
.end
