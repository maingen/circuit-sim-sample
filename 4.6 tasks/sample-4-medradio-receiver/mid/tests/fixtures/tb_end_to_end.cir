End-to-end RF-to-limiter receiver test with testbench quadrature LO
.include "build/sky130_tt.inc"
.include "netlists/primitives.spice"
.include "netlists/bias.spice"
.include "netlists/lna.spice"
.include "netlists/mixer.spice"
.include "netlists/cbpf.spice"
.include "netlists/tuning.spice"
.include "netlists/limiter_rssi.spice"
.include "netlists/qvco.spice"
.include "netlists/synth.spice"
.include "netlists/top.spice"

VDD vdd 0 1
VRF src 0 sin(0 0.5m 403.75meg 0 0 0)
RSRC src rfin 50
VLOIP loi_p 0 sin(0.5 0.5 403meg 0 0 0)
VLOIN loi_n 0 sin(0.5 0.5 403meg 0 0 180)
VLOQP loq_p 0 sin(0.5 0.5 403meg 0 0 90)
VLOQN loq_n 0 sin(0.5 0.5 403meg 0 0 270)
XRX rfin loi_p loi_n loq_p loq_n vo rssi iop ion qop qon rfout vdd 0 receiver_signal_chain
CVO vo 0 1p

.control
set noaskquit
set wr_singlescale
tran 0.4n 20u 2u 0.4n
let vif = v(iop)-v(ion)
let vifcm = 0.5*(v(iop)+v(ion))
let vbuf = v(xrx.lip)-v(xrx.lin)
let vbufcm = 0.5*(v(xrx.lip)+v(xrx.lin))
let vs1 = v(xrx.xlim.s1p)-v(xrx.xlim.s1n)
let vs5 = v(xrx.xlim.s5p)-v(xrx.xlim.s5n)
meas tran e2e_if_vpp pp vif from=10u to=20u
meas tran e2e_if_cm_avg avg vifcm from=10u to=20u
meas tran e2e_buf_vpp pp vbuf from=10u to=20u
meas tran e2e_buf_cm_avg avg vbufcm from=10u to=20u
meas tran e2e_stage1_vpp pp vs1 from=10u to=20u
meas tran e2e_stage5_vpp pp vs5 from=10u to=20u
meas tran e2e_vo_vpp pp v(vo) from=10u to=20u
meas tran e2e_rssi_avg avg v(rssi) from=10u to=20u
meas tran e2e_supply_i avg i(VDD) from=10u to=20u
wrdata results/raw/end_to_end_tran.dat v(src) v(rfout) vif vifcm vbuf vbufcm vs1 vs5 v(vo) v(rssi)
fourier 750k vif
quit
.endc
.end
