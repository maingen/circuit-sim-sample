Eighth-order complex Gm-C bandpass filter AC test
.include "build/sky130_tt.inc"
.include "netlists/primitives.spice"
.include "netlists/bias.spice"
.include "netlists/cbpf.spice"

VDD vdd 0 1
VIP ip 0 dc 0.5 ac 0.5
VIN in 0 dc 0.5 ac -0.5
VQP qp 0 dc 0.5 ac 0
VQN qn 0 dc 0.5 ac 0
XBIAS vdd 0 vbn vbp constant_gm_bias
XFILT ip in qp qn iop ion qop qon vdd 0 vbn vbp complex_bpf8

.control
set noaskquit
set wr_singlescale
op
print v(vbn) v(iop) v(ion) i(VDD)
ac dec 160 10k 20meg
let gain_db = db(v(iop)-v(ion))
meas ac cbpf_gain_750_db find gain_db at=750k
meas ac cbpf_gain_100k_db find gain_db at=100k
meas ac cbpf_gain_3m_db find gain_db at=3meg
wrdata results/raw/cbpf_ac.dat gain_db
quit
.endc
.end
