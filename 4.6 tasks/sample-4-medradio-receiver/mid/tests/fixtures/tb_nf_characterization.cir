SKY130 finger-scaling characterization
.include "build/sky130_tt.inc"
VG gate 0 0.8
VD1 d1 0 1
VD10 d10 0 1
X1 d1 gate 0 0 sky130_fd_pr__nfet_01v8 l=0.3 w=6 nf=1
X10 d10 gate 0 0 sky130_fd_pr__nfet_01v8 l=0.3 w=6 nf=10
.control
op
print i(VD1) i(VD10)
quit
.endc
.end
