Five-stage limiter and RSSI transient test
.include "build/sky130_tt.inc"
.include "netlists/primitives.spice"
.include "netlists/bias.spice"
.include "netlists/limiter_rssi.spice"

VDD vdd 0 1
XBIAS vdd 0 vbn vbp constant_gm_bias
VINP inp 0 sin(0.5 1m 750k 0 0 0)
VINN inn 0 sin(0.5 1m 750k 0 0 180)
XLIM inp inn vo rssi vdd 0 vbn vbp limiting_amp_rssi
CLOAD vo 0 1p

.control
set noaskquit
set wr_singlescale
tran 10n 100u 20u 10n
meas tran limiter_vpp pp v(vo) from=50u to=100u
meas tran rssi_avg avg v(rssi) from=50u to=100u
meas tran limiter_supply_i avg i(VDD) from=50u to=100u
wrdata results/raw/limiter_tran.dat v(inp) v(inn) v(vo) v(rssi)
quit
.endc
.end
