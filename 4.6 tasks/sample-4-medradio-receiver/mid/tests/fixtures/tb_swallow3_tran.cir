Three-bit swallow-counter S=1 test
.include "build/sky130_tt.inc"
.include "netlists/primitives.spice"
.include "netlists/qvco.spice"
.include "netlists/synth.spice"
VDD vdd 0 1
VCLK clk 0 pulse(0 1 20n 1n 1n 48n 100n)
VR reset 0 pulse(1 0 0 1n 1n 50u 100u)
XS clk reset vdd 0 0 terminal q0 q1 q2 vdd 0 swallow_counter3
.control
set wr_singlescale
tran 1n 10u
meas tran ts2 when v(terminal)=0.5 rise=2
meas tran ts12 when v(terminal)=0.5 rise=12
let swallow_out_hz=10/(ts12-ts2)
print swallow_out_hz
wrdata results/raw/swallow3_tran.dat v(clk) v(terminal) v(q0) v(q1) v(q2)
quit
.endc
.end
