* Complete flattened SKY130 MedRadio receiver, harder starter.
.include "/opt/pdk/sky130_tt.inc"
.end
