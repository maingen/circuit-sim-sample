* Flattened por block starter.
.include "/opt/pdk/sky130_tt.inc"
.end
