Complete hierarchy elaboration and short transient smoke test
.include "build/sky130_tt.inc"
.include "netlists/primitives.spice"
.include "netlists/bias.spice"
.include "netlists/lna.spice"
.include "netlists/mixer.spice"
.include "netlists/cbpf.spice"
.include "netlists/tuning.spice"
.include "netlists/limiter_rssi.spice"
.include "netlists/qvco.spice"
.include "netlists/synth.spice"
.include "netlists/top.spice"
VDD vdd 0 1
VRF src 0 sin(0 0.5m 403.576meg 0 0 0)
RS src rfin 50
VR reset 0 1
XFULL rfin vo rssi reset ref fb vctrl iop ion qop qon rfout loi_p loi_n loq_p loq_n vdd 0 medradio_receiver_full
.ic v(xfull.xsyn.vf)=0.5 v(vctrl)=0.5 v(loi_p)=0.51 v(loi_n)=0.49 v(loq_p)=0.5 v(loq_n)=0.5 v(xfull.xftune.n1)=0.1 v(xfull.xftune.n2)=1.0 v(xfull.xftune.n3)=0.1 v(xfull.xftune.n4)=1.0 v(xfull.xftune.n5)=0.1
.control
set noaskquit
tran 0.1n 50n 0 0.1n uic
let vlo=v(loi_p)-v(loi_n)
meas tran full_vdd_i avg i(VDD) from=25n to=50n
meas tran full_rfout_pp pp v(rfout) from=25n to=50n
meas tran full_lo_vpp pp vlo from=25n to=50n
meas tran tf3 when vlo=0 rise=3 td=10n
meas tran tf8 when vlo=0 rise=8 td=10n
let full_lo_hz=5/(tf8-tf3)
print full_lo_hz
write results/raw/full_system_smoke.raw all
quit
.endc
.end
