Limiter test at integrated CBPF common-mode and amplitude
.include "build/sky130_tt.inc"
.include "netlists/primitives.spice"
.include "netlists/bias.spice"
.include "netlists/limiter_rssi.spice"
VDD vdd 0 1
XBIAS vdd 0 vbn vbp constant_gm_bias
VINP inp 0 sin(0.7146 3m 750k 0 0 0)
VINN inn 0 sin(0.7146 3m 750k 0 0 180)
XLIM inp inn vo rssi vdd 0 vbn vbp limiting_amp_rssi
.control
tran 10n 20u 2u 10n
meas tran limiter_level_vpp pp v(vo) from=10u to=20u
meas tran limiter_level_rssi avg v(rssi) from=10u to=20u
quit
.endc
.end
