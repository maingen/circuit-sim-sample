Single Gm-C biquad characterization
.include "build/sky130_tt.inc"
.include "netlists/primitives.spice"
.include "netlists/bias.spice"
.include "netlists/cbpf.spice"
VDD vdd 0 1
VIP ip 0 dc 0.9 ac 0.5
VIN in 0 dc 0.9 ac -0.5
XBIAS vdd 0 vbn vbp constant_gm_bias
XBI ip in op on vdd 0 vbn vbp gm_c_biquad
.control
set wr_singlescale
op
print v(op) v(on)
ac dec 160 10k 20meg
let g=db(v(op)-v(on))
wrdata results/raw/biquad_ac.dat g
quit
.endc
.end
