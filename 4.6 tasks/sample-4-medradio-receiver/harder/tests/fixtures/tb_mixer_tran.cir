Folded mixer RF-to-IF transient conversion test
.include "build/sky130_tt.inc"
.include "netlists/bias.spice"
.include "netlists/mixer.spice"

VDD vdd 0 1
XBIAS vdd 0 vbn vbp constant_gm_bias
VRF rf 0 sin(0 5m 403.75meg 0 0 0)
VLOP lop 0 sin(0.5 0.5 403meg 0 0 0)
VLON lon 0 sin(0.5 0.5 403meg 0 0 180)
XMIX rf lop lon outp outn vdd 0 vbn vbp folded_mixer

.control
set noaskquit
set wr_singlescale
tran 0.1n 12u 2u 0.1n
let vif = v(outp)-v(outn)
meas tran if_vpp pp vif from=4u to=12u
meas tran if_rms rms vif from=4u to=12u
meas tran mixer_supply_i avg i(VDD) from=4u to=12u
wrdata results/raw/mixer_tran.dat v(rf) v(lop) v(outp) v(outn)
fourier 750k v(outp,outn)
quit
.endc
.end
