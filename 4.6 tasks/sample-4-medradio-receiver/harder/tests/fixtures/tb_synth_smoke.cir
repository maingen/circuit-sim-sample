Frequency-synthesizer hierarchy startup and power smoke test
.include "build/sky130_tt.inc"
.include "netlists/primitives.spice"
.include "netlists/qvco.spice"
.include "netlists/synth.spice"
VDD vdd 0 1
VR reset 0 1
XSYN ip in qp qn vctrl ref fb up dn reset vdd 0 frequency_synthesizer
.ic v(XSYN.vf)=0.5 v(vctrl)=0.5 v(ip)=0.51 v(in)=0.49 v(qp)=0.5 v(qn)=0.5
.control
set noaskquit
tran 0.1n 50n 0 0.1n uic
let vlo=v(ip)-v(in)
meas tran synth_supply_i avg i(VDD) from=25n to=50n
meas tran synth_lo_vpp pp vlo from=25n to=50n
meas tran ts3 when vlo=0 rise=3 td=10n
meas tran ts8 when vlo=0 rise=8 td=10n
let synth_lo_hz=5/(ts8-ts3)
print synth_lo_hz
write results/raw/synth_smoke.raw all
quit
.endc
.end
