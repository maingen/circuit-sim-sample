Five-megahertz transistor-level Pierce/crystal oscillator test
.include "build/sky130_tt.inc"
.include "netlists/primitives.spice"
.include "netlists/qvco.spice"
.include "netlists/synth.spice"
VDD vdd 0 1
XOSC ref vdd 0 crystal_osc_5m
.ic v(xosc.xin)=0.49 v(xosc.xout)=0.51
.control
set wr_singlescale
tran 5n 100u 0 5n uic
meas tran ref_vpp pp v(ref) from=50u to=100u
* Ignore oscillator amplitude build-up; use two late restored-clock edges.
meas tran tr150 when v(ref)=0.5 rise=150
meas tran tr250 when v(ref)=0.5 rise=250
let ref_freq_hz=100/(tr250-tr150)
print ref_freq_hz ref_vpp
wrdata results/raw/crystal_tran.dat v(ref) v(xosc.xin) v(xosc.xout)
quit
.endc
.end
