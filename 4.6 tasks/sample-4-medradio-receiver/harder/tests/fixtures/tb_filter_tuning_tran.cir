Filter-tuning relaxation oscillator and replica-biquad test
.include "build/sky130_tt.inc"
.include "netlists/primitives.spice"
.include "netlists/bias.spice"
.include "netlists/cbpf.spice"
.include "netlists/tuning.spice"
VDD vdd 0 1
XBIAS vdd 0 vbn vbp constant_gm_bias
XTUNE tuneclk tune vdd 0 vbn vbp filter_tuning_relaxation
.ic v(XTUNE.n1)=0.1 v(XTUNE.n2)=1.0 v(XTUNE.n3)=0.1 v(XTUNE.n4)=1.0 v(XTUNE.n5)=0.1
.control
set wr_singlescale
tran 2n 20u 0 2n uic
meas tran tt3 when v(tuneclk)=0.5 rise=3
meas tran tt13 when v(tuneclk)=0.5 rise=13
let tune_osc_hz=10/(tt13-tt3)
meas tran tune_avg avg v(tune) from=10u to=20u
print tune_osc_hz
wrdata results/raw/filter_tuning_tran.dat v(tuneclk) v(tune) v(XTUNE.rop) v(XTUNE.ron)
quit
.endc
.end
