Quadrature VCO startup and frequency test
.include "build/sky130_tt.inc"
.include "netlists/qvco.spice"

VDD vdd 0 1
VCTRL vctrl 0 0.5
XVCO ip in qp qn vctrl vdd 0 quadrature_vco
CLOADIP ip 0 20f
CLOADIN in 0 20f
CLOADQP qp 0 20f
CLOADQN qn 0 20f
.ic v(ip)=0.51 v(in)=0.49 v(qp)=0.5 v(qn)=0.5

.control
set noaskquit
set wr_singlescale
tran 25p 3u 0 25p uic
let vdiff = v(ip)-v(in)
meas tran qvco_vpp pp vdiff from=1.5u to=3u
meas tran t100 when v(ip)=0.47 rise=100
meas tran t200 when v(ip)=0.47 rise=200
meas tran tq200 when v(qp)=0.47 rise=200
meas tran qvco_supply_i avg i(VDD) from=1.5u to=3u
let qvco_freq_hz=100/(t200-t100)
let qvco_phase_raw_deg=360*(tq200-t200)*qvco_freq_hz
print qvco_freq_hz qvco_vpp qvco_phase_raw_deg qvco_supply_i
wrdata results/raw/qvco_tran.dat v(ip) v(in) v(qp) v(qn)
quit
.endc
.end
