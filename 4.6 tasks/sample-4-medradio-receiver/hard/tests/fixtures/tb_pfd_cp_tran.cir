PFD and charge-pump phase/frequency response test
.include "build/sky130_tt.inc"
.include "netlists/primitives.spice"
.include "netlists/qvco.spice"
.include "netlists/synth.spice"
VDD vdd 0 1
VREF ref 0 pulse(0 1 20n 2n 2n 98n 200n)
VFB fb 0 pulse(0 1 30n 2n 2n 100.04n 204.08n)
VRST reset 0 pulse(1 0 0 2n 2n 100u 200u)
XPFD ref fb reset up dn vdd 0 phase_frequency_detector
XCP up dn vc vdd 0 charge_pump_20u
CL vc 0 1n
.ic v(vc)=0.5
.control
set wr_singlescale
tran 5n 30u uic
meas tran up_max max v(up) from=5u to=30u
meas tran dn_max max v(dn) from=5u to=30u
meas tran vc_final find v(vc) at=30u
wrdata results/raw/pfd_cp_tran.dat v(ref) v(fb) v(up) v(dn) v(vc)
quit
.endc
.end
