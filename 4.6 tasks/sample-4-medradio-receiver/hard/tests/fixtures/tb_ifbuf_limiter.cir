IF source-follower plus limiter interface test
.include "build/sky130_tt.inc"
.include "netlists/primitives.spice"
.include "netlists/bias.spice"
.include "netlists/limiter_rssi.spice"
VDD vdd 0 1
XBIAS vdd 0 vbn vbp constant_gm_bias
VINP inp 0 sin(0.7146 3m 750k)
VINN inn 0 sin(0.7146 3m 750k 0 0 180)
XBUF inp inn bp bn vdd 0 if_source_follower
XLIM bp bn vo rssi vdd 0 vbn vbp limiting_amp_rssi
.control
tran 10n 20u 2u 10n
let vbuf=v(bp)-v(bn)
let vgate=v(xlim.xs1.gp)-v(xlim.xs1.gn)
let vs1=v(xlim.s1p)-v(xlim.s1n)
let vs5=v(xlim.s5p)-v(xlim.s5n)
meas tran ifbuf_vpp pp vbuf from=10u to=20u
meas tran ifbuf_gate_vpp pp vgate from=10u to=20u
meas tran ifbuf_s1_vpp pp vs1 from=10u to=20u
meas tran ifbuf_s5_vpp pp vs5 from=10u to=20u
meas tran ifbuf_limiter_vpp pp v(vo) from=10u to=20u
meas tran ifbuf_limiter_late_vpp pp v(vo) from=18u to=20u
meas tran ifbuf_gate_late_vpp pp vgate from=18u to=20u
meas tran ifbuf_s1_late_vpp pp vs1 from=18u to=20u
meas tran ifbuf_s5_late_vpp pp vs5 from=18u to=20u
wrdata results/raw/ifbuf_limiter_tran.dat vbuf vs1 vs5 v(vo)
fourier 750k vbuf vgate vs1 vs5 v(vo)
quit
.endc
.end
