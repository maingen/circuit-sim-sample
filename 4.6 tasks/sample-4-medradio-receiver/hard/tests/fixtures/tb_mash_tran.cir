Ten-bit second-order MASH delta-sigma activity test, F=614
.include "build/sky130_tt.inc"
.include "netlists/primitives.spice"
.include "netlists/qvco.spice"
.include "netlists/synth.spice"
VDD vdd 0 1
VCLK clk 0 pulse(0 1 20n 2n 2n 96n 200n)
VR reset 0 pulse(1 0 0 2n 2n 200u 400u)
XM clk reset 0 vdd vdd 0 0 vdd vdd 0 0 vdd y vdd 0 mash10_second_order
.control
set wr_singlescale
tran 20n 10u
meas tran y_avg avg v(y) from=2u to=10u
meas tran y_max max v(y) from=2u to=10u
meas tran y_min min v(y) from=2u to=10u
wrdata results/raw/mash_tran.dat v(clk) v(y)
quit
.endc
.end
