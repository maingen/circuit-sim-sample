* Flattened pfd_cp block starter.
.include "/opt/pdk/sky130_tt.inc"
.end
