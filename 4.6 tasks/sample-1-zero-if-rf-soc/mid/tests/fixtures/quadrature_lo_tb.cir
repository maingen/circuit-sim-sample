* 2.6 GHz quadrature and 25 percent phase verification.
.title quadrature_lo transient
.include ../models/sky130_tt.inc
.include ../netlists/blocks/primitives.spice
.include ../netlists/blocks/clock_pll.spice
.temp 27

VDD vdd 0 1.8
VIP vip 0 SIN(0.9 0.45 2.6g)
VIN vin 0 SIN(0.9 0.45 2.6g 0 0 180)
XQ vip vin lo0 lo90 lo180 lo270 vdd 0 quadrature_lo

.control
set noaskquit
tran 1p 12n 0 1p
meas tran T0 trig v(lo0) val=0.9 rise=20 targ v(lo0) val=0.9 rise=21
meas tran T90 trig v(lo0) val=0.9 rise=20 targ v(lo90) val=0.9 rise=20
meas tran W0 trig v(lo0) val=0.9 rise=20 targ v(lo0) val=0.9 fall=20
meas tran LO0_HIGH max v(lo0) from=4n to=12n
meas tran LO0_LOW min v(lo0) from=4n to=12n
wrdata ../results/raw/quadrature_lo_tran.dat time v(lo0) v(lo90) v(lo180) v(lo270) v(xq.i) v(xq.ib) v(xq.q) v(xq.qb)
print T0 T90 W0 LO0_HIGH LO0_LOW
quit
.endc
.end
