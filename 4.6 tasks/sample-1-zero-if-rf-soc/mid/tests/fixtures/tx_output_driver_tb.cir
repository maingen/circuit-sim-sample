* Cascaded PPA, PA, output match, and 100 ohm differential load verification.
.title TX RF output driver AC
.include ../models/sky130_tt.inc
.include ../netlists/blocks/rf_frontend.spice
VDD vdd 0 1.8
VBN vbn 0 1.0
VIP inp 0 DC 0.8 AC 0.5
VIN inn 0 DC 0.8 AC 0.5 180
XPPA inp inn prp prn vdd 0 vbn pre_power_amp
CCP prp ppap 2p
CCN prn ppan 2p
RBP ppap vbn 5k
RBN ppan vbn 5k
XPA ppap ppan dp dn vdd 0 vbn rf_power_amp
XM dp dn op on 0 output_match
RDIFF op on 100
.control
set noaskquit
op
ac dec 100 1g 4g
let gain=db(v(op)-v(on))
meas ac GAIN_2G6 find gain at=2.6g
meas ac GAIN_PEAK max gain from=1g to=4g
wrdata ../results/raw/tx_output_driver_ac.dat frequency gain
print GAIN_2G6 GAIN_PEAK
quit
.endc
.end
