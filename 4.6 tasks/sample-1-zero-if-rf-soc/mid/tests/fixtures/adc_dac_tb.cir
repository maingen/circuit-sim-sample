* 3-bit flash ADC and 4-bit R-2R DAC verification.
.title converters DC
.include ../models/sky130_tt.inc
.include ../netlists/blocks/primitives.spice
.include ../netlists/blocks/bias.spice
.include ../netlists/blocks/data_converters.spice
.temp 27

VDD vdd 0 1.8
VVIN vin 0 0
XBIAS vdd 0 vbn vbp vcm vbcas bias_core
XADC vin b2 b1 b0 vdd 0 vbn flash_adc3

VB3 b3 0 1.8
VB2 bd2 0 0
VB1 bd1 0 1.8
VB0 bd0 0 0
VREF vref 0 1.8
XDAC b3 bd2 bd1 bd0 dacout vref vdd 0 r2r_dac4
CDAC dacout 0 1p

.control
set noaskquit
dc VVIN 0 1.8 0.01
meas dc B2_010 find v(b2) at=0.10
meas dc B1_010 find v(b1) at=0.10
meas dc B0_010 find v(b0) at=0.10
meas dc B2_080 find v(b2) at=0.80
meas dc B1_080 find v(b1) at=0.80
meas dc B0_080 find v(b0) at=0.80
meas dc B2_100 find v(b2) at=1.00
meas dc B1_100 find v(b1) at=1.00
meas dc B0_100 find v(b0) at=1.00
meas dc B2_170 find v(b2) at=1.70
meas dc B1_170 find v(b1) at=1.70
meas dc B0_170 find v(b0) at=1.70
meas dc DAC_1010 find v(dacout) at=1.00
wrdata ../results/raw/adc_transfer.dat v(vin) v(b2) v(b1) v(b0)
print B2_010 B1_010 B0_010 B2_080 B1_080 B0_080 B2_100 B1_100 B0_100 B2_170 B1_170 B0_170 DAC_1010
quit
.endc
.end
