* LNA operating point, gain, and noise test.
.title rf_lna AC and noise
.include ../models/sky130_tt.inc
.include ../netlists/blocks/bias.spice
.include ../netlists/blocks/rf_frontend.spice
.temp 27

VDD vdd 0 1.8
VIN src 0 DC 0 AC 1
RSRC src in 50
XBIAS vdd 0 vbn vbp vcm vbcas bias_core
XLNA in out vdd 0 vbn vbcas rf_lna
RLOAD out 0 50k
CLOAD out 0 250f

.control
set noaskquit
op
print v(vbn) v(vbcas) v(out) i(vdd)
ac dec 100 100meg 10g
meas ac GAIN_2G6 find vdb(out) at=2.6g
meas ac VGATE_2G6 find vdb(xlna.ng) at=2.6g
meas ac VCAS_2G6 find vdb(xlna.nd) at=2.6g
meas ac FPEAK when vp(out)=0 cross=1
wrdata ../results/raw/lna_ac.dat frequency vdb(out) vp(out)
noise v(out) VIN dec 100 100meg 5g
setplot noise1
wrdata ../results/raw/lna_noise.dat frequency onoise_spectrum inoise_spectrum
quit
.endc
.end
