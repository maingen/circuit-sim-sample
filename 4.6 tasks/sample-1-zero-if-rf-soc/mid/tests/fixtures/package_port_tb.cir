* Lumped package-port insertion verification.
.title package port AC
.include ../netlists/blocks/rf_frontend.spice
VIN pad 0 AC 1
XPKG pad die 0 package_port
RLOAD die 0 50
.control
set noaskquit
ac dec 50 10meg 10g
meas ac GAIN_2G6 find vdb(die) at=2.6g
wrdata ../results/raw/package_port_ac.dat frequency vdb(die)
print GAIN_2G6
quit
.endc
.end
