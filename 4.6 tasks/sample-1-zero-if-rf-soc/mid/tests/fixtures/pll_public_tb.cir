* Public-port integer-N PLL startup and lock test.
.temp 27
VDD vdd 0 1.8
VREF ref 0 PULSE(0 1.8 3.986n 20p 20p 3.056923n 6.153846n)
VREFB refb 0 PULSE(1.8 0 3.986n 20p 20p 3.056923n 6.153846n)
XBIAS vdd 0 vbn vbp vcm vbcas bias_core
XPLL ref refb lo0 lo90 lo180 lo270 vctrl lockmon vdd 0 vbn vbp rf_pll
.ic v(vctrl)=0.9 v(lo0)=0.1 v(lo90)=1.7 v(lo180)=1.6 v(lo270)=0.2

.control
set noaskquit
tran 2p 400n 0 2p uic
let lodiff=v(lo0)-v(lo180)
meas tran LO_PERIOD trig lodiff val=0 rise=900 targ lodiff val=0 rise=901
let LO_FREQ=1/LO_PERIOD
meas tran LO_HIGH max v(lo0) from=300n to=400n
meas tran LO_LOW min v(lo0) from=300n to=400n
meas tran VCTRL_START find v(vctrl) at=20n
meas tran VCTRL_END find v(vctrl) at=390n
meas tran LOCKMON_AVG avg v(lockmon) from=300n to=400n
meas tran SUPPLY_I_AVG avg i(VDD) from=300n to=400n
let SUPPLY_POWER=-SUPPLY_I_AVG*1.8
print LO_PERIOD LO_FREQ LO_HIGH LO_LOW VCTRL_START VCTRL_END LOCKMON_AVG SUPPLY_I_AVG SUPPLY_POWER
quit
.endc
.end
