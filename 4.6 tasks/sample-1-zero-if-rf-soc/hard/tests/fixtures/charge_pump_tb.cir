* Charge-pump polarity and source/sink balance verification.
.title pll_charge_pump transient
.include ../models/sky130_tt.inc
.include ../netlists/blocks/primitives.spice
.include ../netlists/blocks/clock_pll.spice
.temp 27

VDD vdd 0 1.8
VBN vbn 0 1.0
VBP vbp 0 0.50
VHI hi 0 1.8
VLO lo 0 0
XUP hi lo vbp vbn cup vdd 0 pll_charge_pump
XDN lo hi vbp vbn cdn vdd 0 pll_charge_pump
.ic v(cup)=1.0 v(cdn)=1.0 v(xup.por)=1.8 v(xdn.por)=1.8 v(xup.vf)=1.0 v(xdn.vf)=1.0

.control
set noaskquit
tran 10p 100n 0 10p uic
meas tran CUP_START find v(cup) at=10n
meas tran CUP_END find v(cup) at=90n
meas tran CDN_START find v(cdn) at=10n
meas tran CDN_END find v(cdn) at=90n
wrdata ../results/raw/charge_pump_tran.dat time v(cup) v(cdn)
print CUP_START CUP_END CDN_START CDN_END
quit
.endc
.end
