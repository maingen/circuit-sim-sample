* Active-balun differential gain verification.
.title active balun AC
.include ../models/sky130_tt.inc
.include ../netlists/blocks/rf_frontend.spice
VDD vdd 0 1.8
VBN vbn 0 1.0
VCM vcm 0 0.9
VIN in 0 DC 0 AC 1
XB in op on vdd 0 vbn vcm active_balun
.control
set noaskquit
op
ac dec 50 10meg 10g
let diff=v(op)-v(on)
meas ac GAIN_2G6 find vdb(diff) at=2.6g
meas ac PHASE_2G6 find vp(diff) at=2.6g
wrdata ../results/raw/active_balun_ac.dat frequency vdb(diff) vp(diff)
print GAIN_2G6 PHASE_2G6
quit
.endc
.end
