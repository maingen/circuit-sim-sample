* CMOS edge-pulse/SR phase-frequency-detector direction verification.
.title pll_phase_detector transient
.include ../models/sky130_tt.inc
.include ../netlists/blocks/primitives.spice
.include ../netlists/blocks/clock_pll.spice
.temp 27

VDD vdd 0 1.8
VREF ref 0 PULSE(0 1.8 1n 20p 20p 4.96n 10n)
VREFB refb 0 PULSE(1.8 0 1n 20p 20p 4.96n 10n)
VFB fb 0 PULSE(0 1.8 2n 20p 20p 4.96n 10n)
VFBB fbb 0 PULSE(1.8 0 2n 20p 20p 4.96n 10n)
XPFD ref refb fb fbb up dn vdd 0 pll_phase_detector
.ic v(up)=0 v(dn)=0 v(xpfd.upb)=1.8 v(xpfd.dnb)=1.8 v(xpfd.rst)=0

.control
set noaskquit
tran 5p 80n 0 5p uic
meas tran UP_AVG avg v(up) from=20n to=80n
meas tran DN_AVG avg v(dn) from=20n to=80n
meas tran UP_HIGH max v(up) from=20n to=80n
meas tran DN_HIGH max v(dn) from=20n to=80n
wrdata ../results/raw/pfd_tran.dat time v(ref) v(fb) v(up) v(dn)
print UP_AVG DN_AVG UP_HIGH DN_HIGH
quit
.endc
.end
