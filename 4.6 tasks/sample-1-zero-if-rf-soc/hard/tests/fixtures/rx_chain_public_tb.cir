* Public-port RX chain functional and power test.
.temp 27
VDD vdd 0 1.8
VSTIM src 0 SIN(0 50m 2.65g)
RSRC src rfpad 50
VLO0 lo0 0 PULSE(0 1.8 0 2p 2p 94p 384.615p)
VLO90 lo90 0 PULSE(0 1.8 96.154p 2p 2p 94p 384.615p)
VLO180 lo180 0 PULSE(0 1.8 192.308p 2p 2p 94p 384.615p)
VLO270 lo270 0 PULSE(0 1.8 288.462p 2p 2p 94p 384.615p)
VADC adcclk 0 PULSE(0 1.8 1n 20p 20p 3.056923n 6.153846n)
VADCB adcclkb 0 PULSE(1.8 0 1n 20p 20p 3.056923n 6.153846n)
VRST rst 0 PULSE(1.8 0 0 20p 20p 1n 100n)
VATT att 0 1.8
VATTB attb 0 0
XBIAS vdd 0 vbn vbp vcm vbcas bias_core
XRX rfpad lo0 lo90 lo180 lo270 adcclk adcclkb rst att attb i2 i1 i0 q2 q1 q0 gain dcflag qmcflag vdd 0 vbn vcm vbcas rx_chain

.control
set noaskquit
tran 2p 80n 0 2p
meas tran I2_HIGH max v(i2) from=30n to=80n
meas tran I2_LOW min v(i2) from=30n to=80n
meas tran Q2_HIGH max v(q2) from=30n to=80n
meas tran Q2_LOW min v(q2) from=30n to=80n
meas tran GAIN_HIGH max v(gain) from=30n to=80n
meas tran GAIN_LOW min v(gain) from=30n to=80n
meas tran SUPPLY_I_AVG avg i(VDD) from=30n to=80n
let SUPPLY_POWER=-SUPPLY_I_AVG*1.8
print I2_HIGH I2_LOW Q2_HIGH Q2_LOW GAIN_HIGH GAIN_LOW SUPPLY_I_AVG SUPPLY_POWER
quit
.endc
.end
