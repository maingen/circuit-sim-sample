* Feedback-input mux selection and 4-bit 6T SRAM write/retention verification.
.title feedback mux and SRAM support
.include ../models/sky130_tt.inc
.include ../netlists/blocks/primitives.spice
.include ../netlists/blocks/digital_support.spice
.temp 27

VDD vdd 0 1.8
VA ap 0 0.20
VAN an 0 0.30
VB bp 0 0.60
VBN bn 0 0.70
VC cp 0 1.8
VCN cn 0 0
VD dp 0 1.40
VDN dn 0 1.50
VS1 s1 0 1.8
VS0 s0 0 0
XMUX ap an bp bn cp cn dp dn s1 s0 moutp moutn vdd 0 fb_input_mux

VBL3 bl3 0 1.8
VBL3B bl3b 0 0
VBL2 bl2 0 0
VBL2B bl2b 0 1.8
VBL1 bl1 0 1.8
VBL1B bl1b 0 0
VBL0 bl0 0 0
VBL0B bl0b 0 1.8
VWL wl 0 PULSE(0 1.8 1n 20p 20p 4n 100n)
XMEM bl3 bl3b bl2 bl2b bl1 bl1b bl0 bl0b wl mq3 mq2 mq1 mq0 vdd 0 sram6t_bank4
.ic v(mq3)=0 v(xmem.q3b)=1.8 v(mq2)=1.8 v(xmem.q2b)=0 v(mq1)=0 v(xmem.q1b)=1.8 v(mq0)=1.8 v(xmem.q0b)=0

.control
set noaskquit
tran 5p 25n 0 5p uic
meas tran MUXP_AVG avg v(moutp) from=15n to=25n
meas tran MUXN_AVG avg v(moutn) from=15n to=25n
meas tran SRAM_Q3_AVG avg v(mq3) from=15n to=25n
meas tran SRAM_Q2_AVG avg v(mq2) from=15n to=25n
meas tran SRAM_Q1_AVG avg v(mq1) from=15n to=25n
meas tran SRAM_Q0_AVG avg v(mq0) from=15n to=25n
wrdata ../results/raw/memory_mux_tran.dat time v(moutp) v(moutn) v(wl) v(mq3) v(mq2) v(mq1) v(mq0)
print MUXP_AVG MUXN_AVG SRAM_Q3_AVG SRAM_Q2_AVG SRAM_Q1_AVG SRAM_Q0_AVG
quit
.endc
.end
