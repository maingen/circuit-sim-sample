* VGA/ADC-driver gain-state and bandwidth verification.
.title vga adc driver AC
.include ../models/sky130_tt.inc
.include ../netlists/blocks/baseband.spice
.temp 27

VDD vdd 0 1.8
VBN vbn 0 1.0
VGH gh 0 1.8
VGL gl 0 0
VINP inp 0 DC 0.9 AC 0.5
VINN inn 0 DC 0.9 AC 0.5 180
XHI inp inn hp hn gh gl vdd 0 vbn vga_adc_driver
XLO inp inn lp ln gl gh vdd 0 vbn vga_adc_driver

.control
set noaskquit
op
ac dec 100 10k 1g
let hgain=db(v(hp)-v(hn))
let lgain=db(v(lp)-v(ln))
meas ac HIGH_GAIN find hgain at=1meg
meas ac LOW_GAIN find lgain at=1meg
meas ac HIGH_50M find hgain at=50meg
wrdata ../results/raw/vga_ac.dat frequency hgain lgain
print HIGH_GAIN LOW_GAIN HIGH_50M
quit
.endc
.end
