* Public-port LNA coherent two-tone linearity test.
.temp 27
VDD vdd 0 1.8
VTONE1 nsrc 0 SIN(0 10m 2.59g)
VTONE2 src nsrc SIN(0 10m 2.61g)
RSRC src in 50
XBIAS vdd 0 vbn vbp vcm vbcas bias_core
XLNA in out vdd 0 vbn vbcas rf_lna
RLOAD out 0 50k
CLOAD out 0 250f

.control
set noaskquit
tran 2p 150n 0 2p
meas tran OUT_PP pp v(out) from=50n to=150n
wrdata @@RAW_PATH@@ v(out)
print OUT_PP
quit
.endc
.end
