* Passive I/Q upmixer RF conversion verification.
.title passive IQ upmixer transient
.include ../models/sky130_tt.inc
.include ../netlists/blocks/mixer.spice
VVCM vcm 0 0.9
VIP ip 0 1.0
VIN in 0 0.8
VQP qp 0 0.9
VQN qn 0 0.9
VLO0 lo0 0 PULSE(0 1.8 0 2p 2p 94p 384.615p)
VLO90 lo90 0 PULSE(0 1.8 96.154p 2p 2p 94p 384.615p)
VLO180 lo180 0 PULSE(0 1.8 192.308p 2p 2p 94p 384.615p)
VLO270 lo270 0 PULSE(0 1.8 288.462p 2p 2p 94p 384.615p)
XMIX ip in qp qn rfp rfn lo0 lo90 lo180 lo270 vcm 0 passive_iq_upmixer
.control
set noaskquit
tran 2p 20n 0 2p
let diff=v(rfp)-v(rfn)
meas tran RF_DIFF_PP pp diff from=5n to=20n
meas tran RF_PERIOD trig diff val=0 rise=20 targ diff val=0 rise=21
wrdata ../results/raw/mixer_up_tran.dat time diff
print RF_DIFF_PP RF_PERIOD
quit
.endc
.end
