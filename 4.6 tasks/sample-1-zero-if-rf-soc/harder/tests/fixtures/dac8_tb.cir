* Eight-bit RF-path DAC endpoint and monotonic sample verification.
.title eight bit DAC operating points
.include ../models/sky130_tt.inc
.include ../netlists/blocks/primitives.spice
.include ../netlists/blocks/data_converters.spice
VDD vdd 0 1.8
X00 0 0 0 0 0 0 0 0 d00 vdd vdd 0 r2r_dac8
X64 0 vdd 0 0 0 0 0 0 d64 vdd vdd 0 r2r_dac8
X128 vdd 0 0 0 0 0 0 0 d128 vdd vdd 0 r2r_dac8
X192 vdd vdd 0 0 0 0 0 0 d192 vdd vdd 0 r2r_dac8
X255 vdd vdd vdd vdd vdd vdd vdd vdd d255 vdd vdd 0 r2r_dac8
R00 d00 0 1meg
R64 d64 0 1meg
R128 d128 0 1meg
R192 d192 0 1meg
R255 d255 0 1meg
.control
set noaskquit
dc VDD 1.79 1.81 0.01
meas dc CODE_00 find v(d00) at=1.8
meas dc CODE_64 find v(d64) at=1.8
meas dc CODE_128 find v(d128) at=1.8
meas dc CODE_192 find v(d192) at=1.8
meas dc CODE_255 find v(d255) at=1.8
print CODE_00 CODE_64 CODE_128 CODE_192 CODE_255
quit
.endc
.end
