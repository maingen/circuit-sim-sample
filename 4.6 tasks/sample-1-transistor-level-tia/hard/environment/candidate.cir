* Replace this starter with the complete transistor-level TIA requested in instruction.md.
.end
