* artifact: phase24.spice
.option temp=27 method=gear reltol=2e-3
.param T=10n
VDD vdd 0 1.8
VCLK clk 0 PULSE(0 1.8 2n 50p 50p '0.5*T-50p' T)
VCLKB clkb 0 PULSE(1.8 0 2n 50p 50p '0.5*T-50p' T)
VRESET reset 0 PULSE(0 1.8 0 50p 50p 1.5n 1u)
XDUT clk clkb reset vdd 0 p1 p2 p3 p4 p5 p6 p7 p8 p9 p10 p11 p12 p13 p14 p15 p16 p17 p18 p19 p20 p21 p22 p23 p24 PHASE24
.control
set noaskquit
tran 50p 310n
meas tran phase_p1_max_v max v(p1) from=2n to=310n
meas tran phase_p12_max_v max v(p12) from=2n to=310n
meas tran phase_p24_max_v max v(p24) from=2n to=310n
echo FIXTURE_COMPLETE
quit
.endc
.end
