* artifact: dtg.spice
.option temp=27 method=gear reltol=2e-3
VDD vdd 0 1.8
VCLKB clkb 0 PULSE(0 1.8 2n 50p 50p 2n 8n)
VCLKC clkc 0 PULSE(0 1.8 6n 50p 50p 2n 8n)
VEDGEP ep 0 PULSE(0 1.8 0 50p 50p 8n 16n)
VEDGE edge 0 PULSE(1.8 0 0 50p 50p 8n 16n)
XDUT clkb clkc ep edge vdd 0 out DTG
CLOAD out 0 10f
.control
set noaskquit
tran 10p 40n
meas tran dtg_min_v min v(out) from=2n to=40n
meas tran dtg_max_v max v(out) from=2n to=40n
echo FIXTURE_COMPLETE
quit
.endc
.end
