* artifact: adc1bit.spice
.option temp=27 method=gear reltol=2e-3
.param T='1/89.333meg'
VDD vdd 0 1.8
VIP inp 0 SIN(0.328 0.001 1meg)
VIN inn 0 SIN(0.318 0.001 1meg 0 0 180)
VCLK clk 0 PULSE(0 1.8 1n 50p 50p '0.5*T-50p' T)
VCLKB clkb 0 PULSE(1.8 0 1n 50p 50p '0.5*T-50p' T)
XDUT inp inn clk clkb vdd 0 bit bitb ADC1BIT
.control
set noaskquit
tran 50p 1.2u
meas tran adc_bit_min_v min v(bit) from=100n to=1.2u
meas tran adc_bit_max_v max v(bit) from=100n to=1.2u
echo FIXTURE_COMPLETE
quit
.endc
.end
