* artifact: clock_path.spice
.option temp=27 method=gear reltol=3e-3 gmin=1e-10
VDD vdd 0 1.8
VLOP lop 0 SIN(0.9 0.25 1.072g 0 0 0)
VLON lon 0 SIN(0.9 0.25 1.072g 0 0 180)
VRESET reset 0 PULSE(0 1.8 0 50p 50p 1.5n 1u)
XDUT lop lon reset vdd 0 clk clkb p1 p2 p3 p4 p5 p6 p7 p8 p9 p10 p11 p12 p13 p14 p15 p16 p17 p18 p19 p20 p21 p22 p23 p24 adcclk adcclkb CLOCK_PATH
.control
set noaskquit
tran 5p 32n
meas tran clk_period trig v(clk) val=0.9 rise=8 targ v(clk) val=0.9 rise=9
meas tran adc_period trig v(adcclk) val=0.9 rise=1 targ v(adcclk) val=0.9 rise=2
let clock_path_frequency_hz=1/clk_period
let adc_clock_frequency_hz=1/adc_period
print clock_path_frequency_hz adc_clock_frequency_hz
echo FIXTURE_COMPLETE
quit
.endc
.end
