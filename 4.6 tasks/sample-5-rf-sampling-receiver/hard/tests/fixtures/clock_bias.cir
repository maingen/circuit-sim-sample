* artifact: clock_bias.spice
.option temp=27
VDD vdd 0 1.8
XDUT vdd 0 nbias CLOCK_BIAS_3MA
.control
set noaskquit
op
let clock_bias_current_ma=-i(VDD)*1e3
print clock_bias_current_ma
echo FIXTURE_COMPLETE
quit
.endc
.end
