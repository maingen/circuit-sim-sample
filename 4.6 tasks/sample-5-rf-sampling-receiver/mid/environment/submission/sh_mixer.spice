* Replace this starter with a complete flattened physical circuit.
.subckt SH_MIXER IN CLK VBSH VDD VSS OUT
* No devices are provided.
.ends SH_MIXER
