* artifact: clock_slicer.spice
.option temp=27 method=gear reltol=2e-3
VDD vdd 0 1.8
VBIAS nbias 0 0.8527746
VLOP lop 0 SIN(0.9 0.25 1.072g 0 0 0)
VLON lon 0 SIN(0.9 0.25 1.072g 0 0 180)
XDUT lop lon nbias vdd 0 out CLOCK_SLICER
CLOAD out 0 10f
.control
set noaskquit
tran 2p 12n
meas tran out_period trig v(out) val=0.9 rise=6 targ v(out) val=0.9 rise=7
let clock_slicer_frequency_hz=1/out_period
print clock_slicer_frequency_hz
echo FIXTURE_COMPLETE
quit
.endc
.end
