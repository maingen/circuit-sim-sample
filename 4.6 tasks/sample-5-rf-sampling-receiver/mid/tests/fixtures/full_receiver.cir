* artifact: full_receiver.spice
.option temp=27 method=gear maxord=2 reltol=5e-3 gmin=1e-10
VDD vdd 0 1.8
VANT src 0 SIN(0 0.008934 2.413g)
RSRC src ant 50
VLOP lop 0 SIN(0.9 0.25 1.072g 0 0 0)
VLON lon 0 SIN(0.9 0.25 1.072g 0 0 180)
VRESET reset 0 PULSE(0 1.8 0 50p 50p 1.5n 10u)
XDUT ant lop lon reset vdd 0 iop ion qop qon ibit ibitb qbit qbitb adcclk FULL_RECEIVER
VLOADCM loadcm 0 0.55
RIP iop loadcm 50
RIN ion loadcm 50
RQP qop loadcm 50
RQN qon loadcm 50
.control
set noaskquit
tran 20p 1.2u
let idiff=v(iop)-v(ion)
let qdiff=v(qop)-v(qon)
meas tran full_receiver_ibit_min_v min v(ibit) from=300n to=1.2u
meas tran full_receiver_ibit_max_v max v(ibit) from=300n to=1.2u
meas tran full_receiver_qbit_min_v min v(qbit) from=300n to=1.2u
meas tran full_receiver_qbit_max_v max v(qbit) from=300n to=1.2u
meas tran supply_i_avg avg i(VDD) from=300n to=1.2u
let full_receiver_power_mw=-supply_i_avg*1.8*1e3
print full_receiver_power_mw
wrdata iq.dat time idiff qdiff v(adcclk)
echo FIXTURE_COMPLETE
quit
.endc
.end
