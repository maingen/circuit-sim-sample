* artifact: fir23.spice
.option temp=27 method=gear reltol=3e-3
.param T='1/1.072g'
VFP fp 0 SIN(0.3 0.12 268meg)
VFL fl 0 SIN(0.3 0.12 178.666667meg)
VFU fu 0 SIN(0.3 0.12 357.333333meg)
VZ z 0 0.3
VC1 c1 0 PULSE(0 1.8 '2*T' 2p 2p '0.5*T' '24*T')
VC2 c2 0 PULSE(0 1.8 '4*T' 2p 2p '0.5*T' '24*T')
VC3 c3 0 PULSE(0 1.8 '6*T' 2p 2p '0.5*T' '24*T')
VC4 c4 0 PULSE(0 1.8 '8*T' 2p 2p '0.5*T' '24*T')
VC5 c5 0 PULSE(0 1.8 '10*T' 2p 2p '0.5*T' '24*T')
VC6 c6 0 PULSE(0 1.8 '12*T' 2p 2p '0.5*T' '24*T')
VC7 c7 0 PULSE(0 1.8 '14*T' 2p 2p '0.5*T' '24*T')
VC8 c8 0 PULSE(0 1.8 '16*T' 2p 2p '0.5*T' '24*T')
VC9 c9 0 PULSE(0 1.8 '18*T' 2p 2p '0.5*T' '24*T')
VC10 c10 0 PULSE(0 1.8 '20*T' 2p 2p '0.5*T' '24*T')
VC11 c11 0 PULSE(0 1.8 '22*T' 2p 2p '0.5*T' '24*T')
VSUM sum 0 PULSE(0 1.8 '24*T' 2p 2p '0.5*T' '24*T')
XP fp c1 c2 c3 c4 c5 c6 c7 c8 c9 c10 c11 sum pp pn 0 FIR23
XL fl c1 c2 c3 c4 c5 c6 c7 c8 c9 c10 c11 sum lp ln 0 FIR23
XU fu c1 c2 c3 c4 c5 c6 c7 c8 c9 c10 c11 sum up un 0 FIR23
XZ z c1 c2 c3 c4 c5 c6 c7 c8 c9 c10 c11 sum zp zn 0 FIR23
.control
set noaskquit
tran 10p 180n
let pd=v(pp)-v(pn)
let ld=v(lp)-v(ln)
let ud=v(up)-v(un)
let zd=v(zp)-v(zn)
meas tran pass_final find pd at=179.8n
meas tran alias_low_final find ld at=179.8n
meas tran alias_high_final find ud at=179.8n
meas tran zero_final find zd at=179.8n
let pass_signal=abs(pass_final-zero_final)
let alias_low_signal=abs(alias_low_final-zero_final)
let alias_high_signal=abs(alias_high_final-zero_final)
let fir_alias_low_rejection_db=20*log10(pass_signal/alias_low_signal)
let fir_alias_high_rejection_db=20*log10(pass_signal/alias_high_signal)
print fir_alias_low_rejection_db fir_alias_high_rejection_db
echo FIXTURE_COMPLETE
quit
.endc
.end
