* artifact: output_buffer.spice
.option temp=27 method=gear reltol=1e-3
VDD vdd 0 1.8
VTAIL vbtail 0 0.9
VBSF vbsf 0 1.3
VIN in 0 SIN(0.60 0.08 10meg)
XDUT in vbtail vbsf vdd 0 out OUTBUF
VLOADCM loadcm 0 0.55
RLOAD out loadcm 50
.control
set noaskquit
tran 100p 300n
meas tran in_pp pp v(in) from=100n to=300n
meas tran out_pp pp v(out) from=100n to=300n
let output_buffer_gain_db=20*log10(out_pp/in_pp)
print output_buffer_gain_db
echo FIXTURE_COMPLETE
quit
.endc
.end
