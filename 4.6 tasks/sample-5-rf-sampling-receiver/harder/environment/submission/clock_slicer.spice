* Replace this starter with a complete flattened physical circuit.
.subckt CLOCK_SLICER INP INN NBIAS VDD VSS OUT
* No devices are provided.
.ends CLOCK_SLICER
