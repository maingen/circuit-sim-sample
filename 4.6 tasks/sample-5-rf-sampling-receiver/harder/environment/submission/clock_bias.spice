* Replace this starter with a complete flattened physical circuit.
.subckt CLOCK_BIAS_3MA VDD VSS NBIAS
* No devices are provided.
.ends CLOCK_BIAS_3MA
