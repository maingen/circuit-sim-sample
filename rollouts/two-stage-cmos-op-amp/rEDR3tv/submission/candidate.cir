.subckt candidate inp inn out vdd vss
IREF vdd nref 200u
M8 nref nref vss vss NMOS4 W=20u L=0.18u
M5 ntail nref vss vss NMOS4 W=10u L=0.18u
M7 out nref vss vss NMOS4 W=20u L=0.18u
M1 d1 inn ntail vss NMOS4 W=0.474u L=0.18u
M2 d2 inp ntail vss NMOS4 W=0.474u L=0.18u
M3 d1 d1 vdd vdd PMOS4 W=3.08u L=0.22u
M4 d2 d1 vdd vdd PMOS4 W=3.08u L=0.22u
M6 out d2 vdd vdd PMOS4 W=11.6886u L=0.22u
.ends candidate
