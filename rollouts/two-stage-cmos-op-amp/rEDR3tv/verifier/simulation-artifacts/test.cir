S.9.2 two-stage CMOS op amp private fixture
.include cmos018.lib
.subckt candidate inp inn out vdd vss
IREF vdd nref 200u
M8 nref nref vss vss NMOS4 W=20u L=0.18u
M5 ntail nref vss vss NMOS4 W=10u L=0.18u
M7 out nref vss vss NMOS4 W=20u L=0.18u
M1 d1 inn ntail vss NMOS4 W=0.474u L=0.18u
M2 d2 inp ntail vss NMOS4 W=0.474u L=0.18u
M3 d1 d1 vdd vdd PMOS4 W=3.08u L=0.22u
M4 d2 d1 vdd vdd PMOS4 W=3.08u L=0.22u
M6 out d2 vdd vdd PMOS4 W=11.6886u L=0.22u
.ends candidate

VDD vdd 0 1
VSS vss 0 -1
VCM vcm 0 0
VINP inp vcm DC 0 AC 1 SIN(0 0.001 1000.0)
VINN inn vcm DC 0 AC -1 SIN(0 -0.001 1000.0)
XDUT inp inn out vdd vss candidate
.temp 27
.control
set wr_vecnames
set wr_singlescale
dc VCM -1 1 0.001
wrdata cm.dat v(out)
ac dec 400 1.0 100000000.0
wrdata ac.dat v(out)
tran 1e-06 0.02 0.015
wrdata tran.dat v(inp) v(inn) v(out)
quit
.endc
.end
