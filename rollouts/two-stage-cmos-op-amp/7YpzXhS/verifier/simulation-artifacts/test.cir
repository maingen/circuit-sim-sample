S.9.2 two-stage CMOS op amp private fixture
.include cmos018.lib
.subckt candidate inp inn out vdd vss
IREF vdd nb 200u
Mbn nb nb vss vss NMOS4 L=0.74u W=3.1u
Mbn100 nb100 nb vss vss NMOS4 L=0.74u W=1.55u
Mbp100 nb100 nb100 vdd vdd PMOS4 L=0.74u W=30u
Mtail nt nb vss vss NMOS4 L=0.74u W=3.1u
M1 n1 inp nt vss NMOS4 L=0.74u W=250u
M2 n2 inn nt vss NMOS4 L=0.74u W=250u
M3 n1 n1 vdd vdd PMOS4 L=0.74u W=30u
M4 n2 n1 vdd vdd PMOS4 L=0.74u W=30u
M6 out n2 vdd vdd PMOS4 L=0.74u W=42.5566u
M7 out nb vss vss NMOS4 L=0.74u W=2.86u
R1 out vdd 28261.719
R2 out vss 36740.234
Rcm nt out 68007.812
.ends candidate

VDD vdd 0 1
VSS vss 0 -1
VCM vcm 0 0
VINP inp vcm DC 0 AC 1 SIN(0 0.001 1000.0)
VINN inn vcm DC 0 AC -1 SIN(0 -0.001 1000.0)
XDUT inp inn out vdd vss candidate
.temp 27
.control
set wr_vecnames
set wr_singlescale
dc VCM -1 1 0.001
wrdata cm.dat v(out)
ac dec 400 1.0 100000000.0
wrdata ac.dat v(out)
tran 1e-06 0.02 0.015
wrdata tran.dat v(inp) v(inn) v(out)
quit
.endc
.end
