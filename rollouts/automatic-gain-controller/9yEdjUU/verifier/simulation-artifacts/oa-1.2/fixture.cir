AGC private fixture
.include system.lib
* Transistor-level AGC controller
.subckt amp inn inp out vcc vss
* Two-stage CMOS op-amp:
* NMOS differential pair, NMOS tail, PMOS active mirror load,
* PMOS common-source gain stage, Miller RC compensation.
Rbias vcc bb 100k
Mbn bb bb vss vss NMOS_SYS W=5u L=2u
Mtail t bb vss vss NMOS_SYS W=20u L=2u
Md1 d1 inn t vss NMOS_SYS W=40u L=1u
Md2 d2 inp t vss NMOS_SYS W=40u L=1u
Mp1 d1 d1 vcc vcc PMOS_SYS W=20u L=1u
Mp2 d2 d1 vcc vcc PMOS_SYS W=20u L=1u
Mout out d2 vcc vcc PMOS_SYS W=80u L=1u
Mnout out bb vss vss NMOS_SYS W=40u L=2u
Cc out midc 1p
Rc midc d2 1.5k
.ends amp

.subckt candidate detp detn oa pkd agc agc_pkd_ref agc_ref vcc vss
* Differential detector filter: 600 ohm per leg, 150 fF differential
Rfilt1 detp f1 600
Rfilt2 detn f2 600
Cfilt f1 f2 150f

* NPN emitter-follower isolation with NPN current-mirror sinks
Rmbias vcc mb 25k
Qmbias mb mb vss QN_SYS
Qs1 e1 mb vss QN_SYS m=4
Qs2 e2 mb vss QN_SYS m=4
Qf1 vcc f1 e1 QN_SYS
Qf2 vcc f2 e2 QN_SYS

* First closed-loop stage: differential gain 13.97 V/V
* pkd = agc_pkd_ref + (Rf/Rin)*(buffered_detp - buffered_detn)
Rin_a e2 hn 50k
Rf_a hn pkd 701k
Rin_b e1 hp 50k
Rf_b hp agc_pkd_ref 701k
X1 hn hp pkd vcc vss amp

* Second stage: compare pkd with oa to generate agc
* agc = Vref + 0.475*(oa - pkd), decreasing as detector amplitude rises
R2in_a pkd gn 100k
R2f_a gn agc 47.5k
R2in_b oa gp 100k
R2f_b gp vref 47.5k
* Vref from agc_ref (pulled slightly toward vcc for DC target centering)
Rvr1 vcc vref 20k
Rvr2 vref agc_ref 578
X2 gn gp agc vcc vss amp

.ends candidate

VCC vcc 0 3.3
VOA oa 0 1.2
VPKDREF agc_pkd_ref 0 0.8
VAGCREF agc_ref 0 1.2864
VDETN detn 0 3.15
VDETD detp detn PWL(0 0 1u 0 1.01u 20m 3u 20m 3.01u 50m 5u 50m 5.01u 0 6u 0 6.01u 20m 8u 20m 8.01u 50m 10u 50m)
RLOAD agc 0 1Meg
CLOAD agc 0 10p
XDUT detp detn oa pkd agc agc_pkd_ref agc_ref vcc 0 candidate

.control
set wr_vecnames
set wr_singlescale
tran 1n 10u
wrdata tran.dat v(pkd) v(agc)
quit
.endc
.end
