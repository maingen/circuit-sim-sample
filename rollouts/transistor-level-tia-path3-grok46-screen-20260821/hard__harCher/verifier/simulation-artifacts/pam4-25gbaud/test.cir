Transistor-level TIA private fixture
.lib "/opt/ihp-open-pdk/ihp-sg13g2/libs.tech/ngspice/models/cornerMOShv.lib" mos_tt
.lib "/opt/ihp-open-pdk/ihp-sg13g2/libs.tech/ngspice/models/cornerHBT.lib" hbt_typ
.options method=gear maxord=2 reltol=1e-3 abstol=1e-12 vntol=1e-6 itl4=500 rshunt=1e12
R_TB_BUF_LOAD outp outn 100
* IHP SG13G2 25-Gbaud differential optical-receiver front end

* =====================================================================
* References
* =====================================================================
xqref ncs ncs 0 0 npn13G2 Nx=4 selft=0
rcs vcc ncs 1600
ccs ncs 0 12p

rb1 vcc biastia 2585
rb2 biastia 0 2450
cbcb biastia 0 80p

rca1 vcc biascas 1320
rca2 biascas 0 3630
cbca biascas 0 30p

* DCOC reference above idle TIA-EF so the sink is off at zero input
rr1 vcc vref 1280
rr2 vref 0 2020
cref vref 0 40p

* buffer-input CM for AC-coupled interface
rbc1 vcc vbufcm 1065
rbc2 vbufcm 0 2235
cbcf vbufcm 0 20p

* =====================================================================
* TIA P : common-base + cascode + EF
* =====================================================================
xqt_p ntailp ncs 0 0 npn13G2 Nx=6 selft=0
retp inp ntailp 4
xqcb_p ncasp biastia inp 0 npn13G2 Nx=6 selft=0
xqcs_p tiaop biascas ncasp 0 npn13G2 Nx=4 selft=0
ltp vcc tiaopx 0.40n
rtp tiaopx tiaop 168
xqef_p vcc tiaop tiaefp 0 npn13G2 Nx=4 selft=0
rep tiaefp ntefp 10
xqeft_p ntefp ncs 0 0 npn13G2 Nx=3 selft=0

* =====================================================================
* TIA N
* =====================================================================
xqt_n ntailn ncs 0 0 npn13G2 Nx=6 selft=0
retn inn ntailn 4
xqcb_n ncasn biastia inn 0 npn13G2 Nx=6 selft=0
xqcs_n tiaon biascas ncasn 0 npn13G2 Nx=4 selft=0
ltn vcc tiaonx 0.40n
rtn tiaonx tiaon 168
xqef_n vcc tiaon tiaefn 0 npn13G2 Nx=4 selft=0
ren tiaefn ntefn 10
xqeft_n ntefn ncs 0 0 npn13G2 Nx=3 selft=0

* =====================================================================
* DCOC P : high-gain pair, no degeneration; EF + divider onto NMOS
* tiaef > vref -> cea_rp high -> gdc high -> sink
* =====================================================================
xqea_p cea_p tiaefp eea_p 0 npn13G2 Nx=1 selft=0
xqea_rp cea_rp vref eea_p 0 npn13G2 Nx=1 selft=0
reap eea_p tea_p 15
xqeat_p tea_p ncs 0 0 npn13G2 Nx=1 selft=0
rlap vcc cea_p 18000
rlarp vcc cea_rp 18000
xqeb_p vcc cea_rp gdcr_p 0 npn13G2 Nx=1 selft=0
rgp1 gdcr_p gdc_p 8000
rgp2 gdc_p 0 12000
cgp gdc_p 0 10n
xmdc_p inp gdc_p 0 0 sg13_hv_nmos w=10u l=0.45u ng=2 m=24

* =====================================================================
* DCOC N
* =====================================================================
xqea_n cea_n tiaefn eea_n 0 npn13G2 Nx=1 selft=0
xqea_rn cea_rn vref eea_n 0 npn13G2 Nx=1 selft=0
rean eea_n tea_n 15
xqeat_n tea_n ncs 0 0 npn13G2 Nx=1 selft=0
rlan vcc cea_n 18000
rlarn vcc cea_rn 18000
xqeb_n vcc cea_rn gdcr_n 0 npn13G2 Nx=1 selft=0
rgn1 gdcr_n gdc_n 8000
rgn2 gdc_n 0 12000
cgn gdc_n 0 10n
xmdc_n inn gdc_n 0 0 sg13_hv_nmos w=10u l=0.45u ng=2 m=24

* =====================================================================
* VGA1 : tail-current AGC
* =====================================================================
xqv1p vga1p tiaefp ev1p 0 npn13G2 Nx=4 selft=0
xqv1n vga1n tiaefn ev1n 0 npn13G2 Nx=4 selft=0
re1p ev1p tv1 18
re1n ev1n tv1 18
xqv1t tv1 ncs 0 0 npn13G2 Nx=2 selft=0
xmg1 tv1 gc 0 0 sg13_hv_nmos w=5u l=0.55u ng=1 m=2
l1p vcc v1px 0.30n
l1n vcc v1nx 0.30n
rv1p v1px vga1p 155
rv1n v1nx vga1n 155
xqv1efp vcc vga1p v1efp 0 npn13G2 Nx=3 selft=0
xqv1efn vcc vga1n v1efn 0 npn13G2 Nx=3 selft=0
re1ep v1efp nv1p 12
re1en v1efn nv1n 12
xqv1tp nv1p ncs 0 0 npn13G2 Nx=2 selft=0
xqv1tn nv1n ncs 0 0 npn13G2 Nx=2 selft=0

* =====================================================================
* VGA2
* =====================================================================
xqv2p vga2p v1efp ev2p 0 npn13G2 Nx=4 selft=0
xqv2n vga2n v1efn ev2n 0 npn13G2 Nx=4 selft=0
re2p ev2p tv2 16
re2n ev2n tv2 16
xqv2t tv2 ncs 0 0 npn13G2 Nx=2 selft=0
xmg2 tv2 gc 0 0 sg13_hv_nmos w=5u l=0.55u ng=1 m=2
l2p vcc v2px 0.24n
l2n vcc v2nx 0.24n
rv2p v2px vga2p 145
rv2n v2nx vga2n 145
xqv2efp vcc vga2p v2efp 0 npn13G2 Nx=4 selft=0
xqv2efn vcc vga2n v2efn 0 npn13G2 Nx=4 selft=0
re2ep v2efp nb2p 8
re2en v2efn nb2n 8
xqv2tp nb2p ncs 0 0 npn13G2 Nx=3 selft=0
xqv2tn nb2n ncs 0 0 npn13G2 Nx=3 selft=0

* AC-couple VGA to buffer so the buffer test can drive bufinp/bufinn
ccplp v2efp bufinp 8n
ccpln v2efn bufinn 8n
rbip bufinp vbufcm 1800
rbin bufinn vbufcm 1800

* =====================================================================
* Output buffer  Av ~ 1.34
* =====================================================================
xqbp outp bufinp ebp 0 npn13G2 Nx=8 selft=0
xqbn outn bufinn ebn 0 npn13G2 Nx=8 selft=0
rbp ebp tbuf 11
rbn ebn tbuf 11
xqbt tbuf ncsb 0 0 npn13G2 Nx=10 selft=0
rcsb vcc ncsb 142
xqbref ncsb ncsb 0 0 npn13G2 Nx=8 selft=0
ccsb ncsb 0 20p
lbp vcc outpx 0.12n
lbn vcc outnx 0.12n
rlp outpx outp 50
rln outnx outn 50

* delay line ~ 12 ps
ld1p outp d1p 0.20n
cd1p d1p 0 80f
ld2p d1p d2p 0.20n
cd2p d2p 0 80f
ld3p d2p finalp 0.20n
cd3p finalp 0 40f
ld1n outn d1n 0.20n
cd1n d1n 0 80f
ld2n d1n d2n 0.20n
cd2n d2n 0 80f
ld3n d2n finaln 0.20n
cd3n finaln 0 40f

* =====================================================================
* Peak detector
* =====================================================================
cpkd_p v2efp pkdinp 2f
cpkd_n v2efn pkdinn 2f
rpkp pkdinp vpkcm 40000
rpkn pkdinn vpkcm 40000
rpkc1 vcc vpkcm 1210
rpkc2 vpkcm 0 2090
cpkcm vpkcm 0 20p

xqpd_p cpd_p pkdinp epd 0 npn13G2 Nx=4 selft=0
xqpd_n cpd_n pkdinn epd 0 npn13G2 Nx=4 selft=0
repd epd tpd 6
xqpdt tpd ncs 0 0 npn13G2 Nx=4 selft=0
rlpdp vcc cpd_p 280
rlpdn vcc cpd_n 280

* full-wave peak on detp, replica CM on detn
xqpk_a vcc cpd_p detp 0 npn13G2 Nx=3 selft=0
xqpk_b vcc cpd_n detp 0 npn13G2 Nx=3 selft=0
xqpk_r vcc vpkcm detn 0 npn13G2 Nx=6 selft=0
rldp detp vpkld 2200
rldn detn vpkld 2200
chp detp 0 15f
chn detn 0 15f
rld1 vcc vpkld 2400
xqld vpkld vpkld 0 0 npn13G2 Nx=2 selft=0

* =====================================================================
* AGC amplifier ~15 V/V from oa to agc
* =====================================================================
ravg1 detp agcin 12000
ravg2 detn agcin 12000
cagin agcin 0 40p
rdv1 agcin agcs 6350
rdv2 agcs 0 12000
xqagp cagp oa eag 0 npn13G2 Nx=2 selft=0
xqagn cagn agcs eag 0 npn13G2 Nx=2 selft=0
reag eag tagc 58
xqagt tagc ncs 0 0 npn13G2 Nx=2 selft=0
rlagp vcc cagp 2850
rlagn vcc cagn 2850
xqagef vcc cagp agcnet 0 npn13G2 Nx=1 selft=0
rsagc agcnet agc 2200
ragc agc 0 18000
cagc agc 0 20p

* =====================================================================
* Manual / automatic mux : gc = (mc high) ? agc : mgc
* =====================================================================
xinvp nmc mc vcc vcc sg13_hv_pmos w=10u l=0.40u ng=1 m=8
xinvn nmc mc 0 0 sg13_hv_nmos w=6u l=0.45u ng=1 m=8
xtgmp gc mc mgc vcc sg13_hv_pmos w=10u l=0.40u ng=1 m=30
xtgmn gc nmc mgc 0 sg13_hv_nmos w=10u l=0.45u ng=1 m=30
xtgap gc nmc agc vcc sg13_hv_pmos w=10u l=0.40u ng=1 m=30
xtgan gc mc agc 0 sg13_hv_nmos w=10u l=0.45u ng=1 m=30
cgc gc 0 4p

* supply-current trim
xpdum ndum ncs 0 0 npn13G2 Nx=8 selft=0
rdum vcc ndum 400

V_TB_VCC vcc 0 3.3
V_TB_MC mc 0 0
V_TB_MGC mgc 0 1.4
V_TB_OA oa 0 1.2
I_TB_P 0 inp PWL(
+ 0 3.33333333e-05 3.9e-11 3.33333333e-05 4e-11 3.33333333e-05 7.9e-11 3.33333333e-05 8e-11 3.33333333e-05 1.19e-10 3.33333333e-05 1.2e-10 9.99999999e-05 1.59e-10 9.99999999e-05
+ 1.6e-10 3.33333333e-05 1.99e-10 3.33333333e-05 2e-10 -9.99999999e-05 2.39e-10 -9.99999999e-05 2.4e-10 -3.33333333e-05 2.79e-10 -3.33333333e-05 2.8e-10 -9.99999999e-05 3.19e-10 -9.99999999e-05
+ 3.2e-10 9.99999999e-05 3.59e-10 9.99999999e-05 3.6e-10 9.99999999e-05 3.99e-10 9.99999999e-05 4e-10 -9.99999999e-05 4.39e-10 -9.99999999e-05 4.4e-10 3.33333333e-05 4.79e-10 3.33333333e-05
+ 4.8e-10 9.99999999e-05 5.19e-10 9.99999999e-05 5.2e-10 9.99999999e-05 5.59e-10 9.99999999e-05 5.6e-10 -3.33333333e-05 5.99e-10 -3.33333333e-05 6e-10 9.99999999e-05 6.39e-10 9.99999999e-05
+ 6.4e-10 -3.33333333e-05 6.79e-10 -3.33333333e-05 6.8e-10 3.33333333e-05 7.19e-10 3.33333333e-05 7.2e-10 -9.99999999e-05 7.59e-10 -9.99999999e-05 7.6e-10 -9.99999999e-05 7.99e-10 -9.99999999e-05
+ 8e-10 -3.33333333e-05 8.39e-10 -3.33333333e-05 8.4e-10 -3.33333333e-05 8.79e-10 -3.33333333e-05 8.8e-10 3.33333333e-05 9.19e-10 3.33333333e-05 9.2e-10 -3.33333333e-05 9.59e-10 -3.33333333e-05
+ 9.6e-10 -3.33333333e-05 9.99e-10 -3.33333333e-05 1e-09 9.99999999e-05 1.039e-09 9.99999999e-05 1.04e-09 -9.99999999e-05 1.079e-09 -9.99999999e-05 1.08e-09 9.99999999e-05 1.119e-09 9.99999999e-05
+ 1.12e-09 3.33333333e-05 1.159e-09 3.33333333e-05 1.16e-09 -3.33333333e-05 1.199e-09 -3.33333333e-05 1.2e-09 -9.99999999e-05 1.239e-09 -9.99999999e-05 1.24e-09 3.33333333e-05 1.279e-09 3.33333333e-05
+ 1.28e-09 3.33333333e-05 1.319e-09 3.33333333e-05 1.32e-09 3.33333333e-05 1.359e-09 3.33333333e-05 1.36e-09 9.99999999e-05 1.399e-09 9.99999999e-05 1.4e-09 3.33333333e-05 1.439e-09 3.33333333e-05
+ 1.44e-09 -9.99999999e-05 1.479e-09 -9.99999999e-05 1.48e-09 -3.33333333e-05 1.519e-09 -3.33333333e-05 1.52e-09 -9.99999999e-05 1.559e-09 -9.99999999e-05 1.56e-09 9.99999999e-05 1.599e-09 9.99999999e-05
+ 1.6e-09 9.99999999e-05 1.639e-09 9.99999999e-05 1.64e-09 -9.99999999e-05 1.679e-09 -9.99999999e-05 1.68e-09 3.33333333e-05 1.719e-09 3.33333333e-05 1.72e-09 9.99999999e-05 1.759e-09 9.99999999e-05
+ 1.76e-09 9.99999999e-05 1.799e-09 9.99999999e-05 1.8e-09 -3.33333333e-05 1.839e-09 -3.33333333e-05 1.84e-09 9.99999999e-05 1.879e-09 9.99999999e-05 1.88e-09 -3.33333333e-05 1.919e-09 -3.33333333e-05
+ 1.92e-09 3.33333333e-05 1.959e-09 3.33333333e-05 1.96e-09 -9.99999999e-05 1.999e-09 -9.99999999e-05 2e-09 -9.99999999e-05 2.039e-09 -9.99999999e-05 2.04e-09 -3.33333333e-05 2.079e-09 -3.33333333e-05
+ 2.08e-09 -3.33333333e-05 2.119e-09 -3.33333333e-05 2.12e-09 3.33333333e-05 2.159e-09 3.33333333e-05 2.16e-09 -3.33333333e-05 2.199e-09 -3.33333333e-05 2.2e-09 -3.33333333e-05 2.239e-09 -3.33333333e-05
+ 2.24e-09 9.99999999e-05 2.279e-09 9.99999999e-05 2.28e-09 -9.99999999e-05 2.319e-09 -9.99999999e-05 2.32e-09 9.99999999e-05 2.359e-09 9.99999999e-05 2.36e-09 3.33333333e-05 2.399e-09 3.33333333e-05
+ 2.4e-09 -3.33333333e-05 2.439e-09 -3.33333333e-05 2.44e-09 -9.99999999e-05 2.479e-09 -9.99999999e-05 2.48e-09 3.33333333e-05 2.519e-09 3.33333333e-05 2.52e-09 3.33333333e-05 2.559e-09 3.33333333e-05
+ 2.56e-09 3.33333333e-05 2.599e-09 3.33333333e-05 2.6e-09 9.99999999e-05 2.639e-09 9.99999999e-05 2.64e-09 3.33333333e-05 2.679e-09 3.33333333e-05 2.68e-09 -9.99999999e-05 2.719e-09 -9.99999999e-05
+ 2.72e-09 -3.33333333e-05 2.759e-09 -3.33333333e-05 2.76e-09 -9.99999999e-05 2.799e-09 -9.99999999e-05 2.8e-09 9.99999999e-05 2.839e-09 9.99999999e-05 2.84e-09 9.99999999e-05 2.879e-09 9.99999999e-05
+ 2.88e-09 -9.99999999e-05 2.919e-09 -9.99999999e-05 2.92e-09 3.33333333e-05 2.959e-09 3.33333333e-05 2.96e-09 9.99999999e-05 2.999e-09 9.99999999e-05 3e-09 9.99999999e-05 3.039e-09 9.99999999e-05
+ 3.04e-09 -3.33333333e-05 3.079e-09 -3.33333333e-05 3.08e-09 9.99999999e-05 3.119e-09 9.99999999e-05 3.12e-09 -3.33333333e-05 3.159e-09 -3.33333333e-05 3.16e-09 3.33333333e-05 3.199e-09 3.33333333e-05
+ 3.2e-09 -9.99999999e-05 3.239e-09 -9.99999999e-05 3.24e-09 -9.99999999e-05 3.279e-09 -9.99999999e-05 3.28e-09 -3.33333333e-05 3.319e-09 -3.33333333e-05 3.32e-09 -3.33333333e-05 3.359e-09 -3.33333333e-05
+ 3.36e-09 3.33333333e-05 3.399e-09 3.33333333e-05 3.4e-09 -3.33333333e-05 3.439e-09 -3.33333333e-05 3.44e-09 -3.33333333e-05 3.479e-09 -3.33333333e-05 3.48e-09 9.99999999e-05 3.519e-09 9.99999999e-05
+ 3.52e-09 -9.99999999e-05 3.559e-09 -9.99999999e-05 3.56e-09 9.99999999e-05 3.599e-09 9.99999999e-05 3.6e-09 3.33333333e-05 3.639e-09 3.33333333e-05 3.64e-09 -3.33333333e-05 3.679e-09 -3.33333333e-05
+ 3.68e-09 -9.99999999e-05 3.719e-09 -9.99999999e-05 3.72e-09 3.33333333e-05 3.759e-09 3.33333333e-05 3.76e-09 3.33333333e-05 3.799e-09 3.33333333e-05 3.8e-09 3.33333333e-05 3.839e-09 3.33333333e-05
+ 3.84e-09 9.99999999e-05 3.879e-09 9.99999999e-05 3.88e-09 3.33333333e-05 3.919e-09 3.33333333e-05 3.92e-09 -9.99999999e-05 3.959e-09 -9.99999999e-05 3.96e-09 -3.33333333e-05 4e-09 -3.33333333e-05
+ )
I_TB_N inn 0 PWL(
+ 0 3.33333333e-05 3.9e-11 3.33333333e-05 4e-11 3.33333333e-05 7.9e-11 3.33333333e-05 8e-11 3.33333333e-05 1.19e-10 3.33333333e-05 1.2e-10 9.99999999e-05 1.59e-10 9.99999999e-05
+ 1.6e-10 3.33333333e-05 1.99e-10 3.33333333e-05 2e-10 -9.99999999e-05 2.39e-10 -9.99999999e-05 2.4e-10 -3.33333333e-05 2.79e-10 -3.33333333e-05 2.8e-10 -9.99999999e-05 3.19e-10 -9.99999999e-05
+ 3.2e-10 9.99999999e-05 3.59e-10 9.99999999e-05 3.6e-10 9.99999999e-05 3.99e-10 9.99999999e-05 4e-10 -9.99999999e-05 4.39e-10 -9.99999999e-05 4.4e-10 3.33333333e-05 4.79e-10 3.33333333e-05
+ 4.8e-10 9.99999999e-05 5.19e-10 9.99999999e-05 5.2e-10 9.99999999e-05 5.59e-10 9.99999999e-05 5.6e-10 -3.33333333e-05 5.99e-10 -3.33333333e-05 6e-10 9.99999999e-05 6.39e-10 9.99999999e-05
+ 6.4e-10 -3.33333333e-05 6.79e-10 -3.33333333e-05 6.8e-10 3.33333333e-05 7.19e-10 3.33333333e-05 7.2e-10 -9.99999999e-05 7.59e-10 -9.99999999e-05 7.6e-10 -9.99999999e-05 7.99e-10 -9.99999999e-05
+ 8e-10 -3.33333333e-05 8.39e-10 -3.33333333e-05 8.4e-10 -3.33333333e-05 8.79e-10 -3.33333333e-05 8.8e-10 3.33333333e-05 9.19e-10 3.33333333e-05 9.2e-10 -3.33333333e-05 9.59e-10 -3.33333333e-05
+ 9.6e-10 -3.33333333e-05 9.99e-10 -3.33333333e-05 1e-09 9.99999999e-05 1.039e-09 9.99999999e-05 1.04e-09 -9.99999999e-05 1.079e-09 -9.99999999e-05 1.08e-09 9.99999999e-05 1.119e-09 9.99999999e-05
+ 1.12e-09 3.33333333e-05 1.159e-09 3.33333333e-05 1.16e-09 -3.33333333e-05 1.199e-09 -3.33333333e-05 1.2e-09 -9.99999999e-05 1.239e-09 -9.99999999e-05 1.24e-09 3.33333333e-05 1.279e-09 3.33333333e-05
+ 1.28e-09 3.33333333e-05 1.319e-09 3.33333333e-05 1.32e-09 3.33333333e-05 1.359e-09 3.33333333e-05 1.36e-09 9.99999999e-05 1.399e-09 9.99999999e-05 1.4e-09 3.33333333e-05 1.439e-09 3.33333333e-05
+ 1.44e-09 -9.99999999e-05 1.479e-09 -9.99999999e-05 1.48e-09 -3.33333333e-05 1.519e-09 -3.33333333e-05 1.52e-09 -9.99999999e-05 1.559e-09 -9.99999999e-05 1.56e-09 9.99999999e-05 1.599e-09 9.99999999e-05
+ 1.6e-09 9.99999999e-05 1.639e-09 9.99999999e-05 1.64e-09 -9.99999999e-05 1.679e-09 -9.99999999e-05 1.68e-09 3.33333333e-05 1.719e-09 3.33333333e-05 1.72e-09 9.99999999e-05 1.759e-09 9.99999999e-05
+ 1.76e-09 9.99999999e-05 1.799e-09 9.99999999e-05 1.8e-09 -3.33333333e-05 1.839e-09 -3.33333333e-05 1.84e-09 9.99999999e-05 1.879e-09 9.99999999e-05 1.88e-09 -3.33333333e-05 1.919e-09 -3.33333333e-05
+ 1.92e-09 3.33333333e-05 1.959e-09 3.33333333e-05 1.96e-09 -9.99999999e-05 1.999e-09 -9.99999999e-05 2e-09 -9.99999999e-05 2.039e-09 -9.99999999e-05 2.04e-09 -3.33333333e-05 2.079e-09 -3.33333333e-05
+ 2.08e-09 -3.33333333e-05 2.119e-09 -3.33333333e-05 2.12e-09 3.33333333e-05 2.159e-09 3.33333333e-05 2.16e-09 -3.33333333e-05 2.199e-09 -3.33333333e-05 2.2e-09 -3.33333333e-05 2.239e-09 -3.33333333e-05
+ 2.24e-09 9.99999999e-05 2.279e-09 9.99999999e-05 2.28e-09 -9.99999999e-05 2.319e-09 -9.99999999e-05 2.32e-09 9.99999999e-05 2.359e-09 9.99999999e-05 2.36e-09 3.33333333e-05 2.399e-09 3.33333333e-05
+ 2.4e-09 -3.33333333e-05 2.439e-09 -3.33333333e-05 2.44e-09 -9.99999999e-05 2.479e-09 -9.99999999e-05 2.48e-09 3.33333333e-05 2.519e-09 3.33333333e-05 2.52e-09 3.33333333e-05 2.559e-09 3.33333333e-05
+ 2.56e-09 3.33333333e-05 2.599e-09 3.33333333e-05 2.6e-09 9.99999999e-05 2.639e-09 9.99999999e-05 2.64e-09 3.33333333e-05 2.679e-09 3.33333333e-05 2.68e-09 -9.99999999e-05 2.719e-09 -9.99999999e-05
+ 2.72e-09 -3.33333333e-05 2.759e-09 -3.33333333e-05 2.76e-09 -9.99999999e-05 2.799e-09 -9.99999999e-05 2.8e-09 9.99999999e-05 2.839e-09 9.99999999e-05 2.84e-09 9.99999999e-05 2.879e-09 9.99999999e-05
+ 2.88e-09 -9.99999999e-05 2.919e-09 -9.99999999e-05 2.92e-09 3.33333333e-05 2.959e-09 3.33333333e-05 2.96e-09 9.99999999e-05 2.999e-09 9.99999999e-05 3e-09 9.99999999e-05 3.039e-09 9.99999999e-05
+ 3.04e-09 -3.33333333e-05 3.079e-09 -3.33333333e-05 3.08e-09 9.99999999e-05 3.119e-09 9.99999999e-05 3.12e-09 -3.33333333e-05 3.159e-09 -3.33333333e-05 3.16e-09 3.33333333e-05 3.199e-09 3.33333333e-05
+ 3.2e-09 -9.99999999e-05 3.239e-09 -9.99999999e-05 3.24e-09 -9.99999999e-05 3.279e-09 -9.99999999e-05 3.28e-09 -3.33333333e-05 3.319e-09 -3.33333333e-05 3.32e-09 -3.33333333e-05 3.359e-09 -3.33333333e-05
+ 3.36e-09 3.33333333e-05 3.399e-09 3.33333333e-05 3.4e-09 -3.33333333e-05 3.439e-09 -3.33333333e-05 3.44e-09 -3.33333333e-05 3.479e-09 -3.33333333e-05 3.48e-09 9.99999999e-05 3.519e-09 9.99999999e-05
+ 3.52e-09 -9.99999999e-05 3.559e-09 -9.99999999e-05 3.56e-09 9.99999999e-05 3.599e-09 9.99999999e-05 3.6e-09 3.33333333e-05 3.639e-09 3.33333333e-05 3.64e-09 -3.33333333e-05 3.679e-09 -3.33333333e-05
+ 3.68e-09 -9.99999999e-05 3.719e-09 -9.99999999e-05 3.72e-09 3.33333333e-05 3.759e-09 3.33333333e-05 3.76e-09 3.33333333e-05 3.799e-09 3.33333333e-05 3.8e-09 3.33333333e-05 3.839e-09 3.33333333e-05
+ 3.84e-09 9.99999999e-05 3.879e-09 9.99999999e-05 3.88e-09 3.33333333e-05 3.919e-09 3.33333333e-05 3.92e-09 -9.99999999e-05 3.959e-09 -9.99999999e-05 3.96e-09 -3.33333333e-05 4e-09 -3.33333333e-05
+ )
.control
set wr_vecnames
set wr_singlescale
tran 1p 4n 0 1p
wrdata pam4.dat v(finalp) v(finaln)
quit
.endc
.end
