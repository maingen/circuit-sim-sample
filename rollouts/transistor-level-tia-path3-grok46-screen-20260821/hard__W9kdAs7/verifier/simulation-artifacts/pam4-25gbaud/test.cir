Transistor-level TIA private fixture
.lib "/opt/ihp-open-pdk/ihp-sg13g2/libs.tech/ngspice/models/cornerMOShv.lib" mos_tt
.lib "/opt/ihp-open-pdk/ihp-sg13g2/libs.tech/ngspice/models/cornerHBT.lib" hbt_typ
.options method=gear maxord=2 reltol=1e-3 abstol=1e-12 vntol=1e-6 itl4=500 rshunt=1e12
R_TB_BUF_LOAD outp outn 100
* IHP SG13G2 25-Gbaud differential optical-receiver front end
* External fixtures (verifier removes independent sources)

* =====================================================================
* Bias
* =====================================================================
Rcas1 vcc casb 2.40k
Rcas2 casb 0 4.20k
Ccas casb 0 5p

Rcm1 vcc vcmref 2.20k
Rcm2 vcmref 0 2.50k
Ccm vcmref 0 5p

Xmnptrim vcc oa 0 0 sg13_hv_nmos w=10.0u l=0.45u ng=1 m=20

* =====================================================================
* TIA P  (RGC + cascode + EF + MOS DC-cancel)
* =====================================================================
Xqreg_p creg_p inp 0 0 npn13G2 Nx=4 selft=0
Rreg_p vcc creg_p 12.55k
Creg_p creg_p 0 2f

Xqin_p ncas_p creg_p inp 0 npn13G2 Nx=6 selft=0
Xmnin_p inp oa 0 0 sg13_hv_nmos w=10.0u l=0.45u ng=1 m=5
Xqcas_p col_p casb ncas_p 0 npn13G2 Nx=6 selft=0
Rc_p vcc lrc_p 208
Lrc_p lrc_p col_p 0.34n
Xqef_p vcc col_p tia_p 0 npn13G2 Nx=3 selft=0
Xmnef_p tia_p oa 0 0 sg13_hv_nmos w=4.0u l=0.45u ng=1 m=2

Xmnota_tp colm_p tia_p otae_p 0 sg13_hv_nmos w=2.0u l=0.50u ng=1 m=2
Xmnota_rp dum_p vcmref otae_p 0 sg13_hv_nmos w=2.0u l=0.50u ng=1 m=2
Rdum_p vcc dum_p 6.0k
Cdum_p dum_p 0 200f
Xmnota_bp otae_p oa 0 0 sg13_hv_nmos w=2.0u l=0.50u ng=1 m=1
Xmndio_p colm_p colm_p 0 0 sg13_hv_nmos w=3.0u l=0.50u ng=1 m=1
Xmncan_p inp colm_p 0 0 sg13_hv_nmos w=10.0u l=0.45u ng=1 m=8
Cint_p colm_p 0 12n
Rint_p colm_p 0 150k

* =====================================================================
* TIA N
* =====================================================================
Xqreg_n creg_n inn 0 0 npn13G2 Nx=4 selft=0
Rreg_n vcc creg_n 12.55k
Creg_n creg_n 0 2f

Xqin_n ncas_n creg_n inn 0 npn13G2 Nx=6 selft=0
Xmnin_n inn oa 0 0 sg13_hv_nmos w=10.0u l=0.45u ng=1 m=5
Xqcas_n col_n casb ncas_n 0 npn13G2 Nx=6 selft=0
Rc_n vcc lrc_n 208
Lrc_n lrc_n col_n 0.34n
Xqef_n vcc col_n tia_n 0 npn13G2 Nx=3 selft=0
Xmnef_n tia_n oa 0 0 sg13_hv_nmos w=4.0u l=0.45u ng=1 m=2

Xmnota_tn colm_n tia_n otae_n 0 sg13_hv_nmos w=2.0u l=0.50u ng=1 m=2
Xmnota_rn dum_n vcmref otae_n 0 sg13_hv_nmos w=2.0u l=0.50u ng=1 m=2
Rdum_n vcc dum_n 6.0k
Cdum_n dum_n 0 200f
Xmnota_bn otae_n oa 0 0 sg13_hv_nmos w=2.0u l=0.50u ng=1 m=1
Xmndio_n colm_n colm_n 0 0 sg13_hv_nmos w=3.0u l=0.50u ng=1 m=1
Xmncan_n inn colm_n 0 0 sg13_hv_nmos w=10.0u l=0.45u ng=1 m=8
Cint_n colm_n 0 12n
Rint_n colm_n 0 150k

Cac_p tia_p vgain_p 20n
Cac_n tia_n vgain_n 20n
Rbac_p vgain_p vcmref 2.2k
Rbac_n vgain_n vcmref 2.2k

* =====================================================================
* Manual / automatic gain select
* =====================================================================
Xsw_man gc mc mgc vcc sg13_hv_pmos w=10.0u l=0.40u ng=1 m=30
Xsw_auto gc mc agc 0 sg13_hv_nmos w=10.0u l=0.45u ng=1 m=30
Cgc gc 0 5f

* =====================================================================
* VGA 1
* =====================================================================
Xqvg1p v1p vgain_p ve1p 0 npn13G2 Nx=4 selft=0
Xqvg1n v1n vgain_n ve1n 0 npn13G2 Nx=4 selft=0
Re1p ve1p ve1c 8
Re1n ve1n ve1c 8
Xmnvg1 ve1c oa 0 0 sg13_hv_nmos w=4.0u l=0.45u ng=1 m=1
Xmnvar1 ve1c gc 0 0 sg13_hv_nmos w=10.0u l=0.45u ng=1 m=12
Rl1p vcc ll1p 72
Ll1p ll1p v1p 0.18n
Rl1n vcc ll1n 72
Ll1n ll1n v1n 0.18n
Xqef1p vcc v1p vg1p 0 npn13G2 Nx=3 selft=0
Xqef1n vcc v1n vg1n 0 npn13G2 Nx=3 selft=0
Xmnef1p vg1p oa 0 0 sg13_hv_nmos w=4.0u l=0.45u ng=1 m=2
Xmnef1n vg1n oa 0 0 sg13_hv_nmos w=4.0u l=0.45u ng=1 m=2

* =====================================================================
* VGA 2
* =====================================================================
Xqvg2p v2p vg1p ve2p 0 npn13G2 Nx=4 selft=0
Xqvg2n v2n vg1n ve2n 0 npn13G2 Nx=4 selft=0
Re2p ve2p ve2c 8
Re2n ve2n ve2c 8
Xmnvg2 ve2c oa 0 0 sg13_hv_nmos w=4.0u l=0.45u ng=1 m=1
Xmnvar2 ve2c gc 0 0 sg13_hv_nmos w=10.0u l=0.45u ng=1 m=12
Rl2p vcc ll2p 66
Ll2p ll2p v2p 0.16n
Rl2n vcc ll2n 66
Ll2n ll2n v2n 0.16n
Xqef2p vcc v2p bufinp 0 npn13G2 Nx=4 selft=0
Xqef2n vcc v2n bufinn 0 npn13G2 Nx=4 selft=0
Xmnef2p bufinp oa 0 0 sg13_hv_nmos w=5.0u l=0.45u ng=1 m=2
Xmnef2n bufinn oa 0 0 sg13_hv_nmos w=5.0u l=0.45u ng=1 m=2

* =====================================================================
* Output buffer
* =====================================================================
Xqbp colb_p bufinp veop 0 npn13G2 Nx=8 selft=0
Xqbn colb_n bufinn veon 0 npn13G2 Nx=8 selft=0
Reop veop veoc 30
Reon veon veoc 30
Xmnbuf veoc oa 0 0 sg13_hv_nmos w=10.0u l=0.45u ng=1 m=42
Rlp vcc colb_p 50
Rln vcc colb_n 50
Llp colb_p outp 0.58n
Lln colb_n outn 0.58n
Rdp colb_p outp 160
Rdn colb_n outn 160
Clp outp 0 22f
Cln outn 0 22f
Rtie_p finalp outp 1m
Rtie_n finaln outn 1m

* =====================================================================
* Peak detector: 33 GHz preamp + Gilbert self-mixer
* =====================================================================
Riso_p bufinp pkdinp 1.0meg
Riso_n bufinn pkdinn 1.0meg

Xqpd_ap pdap pkdinp vepd 0 npn13G2 Nx=2 selft=0
Xqpd_an pdan pkdinn vepd 0 npn13G2 Nx=2 selft=0
Xmnpd_t vepd oa 0 0 sg13_hv_nmos w=8.0u l=0.45u ng=1 m=3
Rpdap vcc lpdap 110
Lpdp lpdap pdap 0.20n
Rpdan vcc lpdan 110
Lpdn lpdan pdan 0.20n

Cgil_lp pdap glo_p 2p
Cgil_ln pdan glo_n 2p
Cgil_up pdap grf_p 2p
Cgil_un pdan grf_n 2p
Rgil_lp glo_p vgacm_g 1.5k
Rgil_ln glo_n vgacm_g 1.5k
Rgil_up grf_p vgacm_g 1.5k
Rgil_un grf_n vgacm_g 1.5k
Rvg1 vcc vgacm_g 1.6k
Rvg2 vgacm_g 0 2.4k
Cvgacm_g vgacm_g 0 2p

Xqgl_p cgil_p glo_p vegil 0 npn13G2 Nx=2 selft=0
Xqgl_n cgil_n glo_n vegil 0 npn13G2 Nx=2 selft=0
Xmngil vegil oa 0 0 sg13_hv_nmos w=8.0u l=0.45u ng=1 m=3
Xqg_pp detn grf_p cgil_p 0 npn13G2 Nx=2 selft=0
Xqg_pn detp grf_n cgil_p 0 npn13G2 Nx=2 selft=0
Xqg_np detp grf_p cgil_n 0 npn13G2 Nx=2 selft=0
Xqg_nn detn grf_n cgil_n 0 npn13G2 Nx=2 selft=0
Rdetp vcc detp 2200
Rdetn vcc detn 2200
Cdetp detp 0 15f
Cdetn detn 0 15f

* =====================================================================
* AGC amplifier (target 15.03 V/V)
* =====================================================================
Ragiso_p detp aginp 4.0k
Ragiso_n detn aginn 4.0k
Xqag_p agcpre aginp veag 0 npn13G2 Nx=2 selft=0
Xqag_n agcdum aginn veag 0 npn13G2 Nx=2 selft=0
Xmnag veag oa 0 0 sg13_hv_nmos w=3.0u l=0.45u ng=1 m=1
Ragp vcc agcpre 10.9k
Ragd vcc agcdum 10.9k
Xqagef vcc agcpre agcint 0 npn13G2 Nx=2 selft=0
Xmnagef agcint oa 0 0 sg13_hv_nmos w=3.0u l=0.45u ng=1 m=1
Ragc_s agcint agc 1.5k
Cagc agc 0 4f

V_TB_VCC vcc 0 3.3
V_TB_MC mc 0 0
V_TB_MGC mgc 0 1.4
V_TB_OA oa 0 1.2
I_TB_P 0 inp PWL(
+ 0 3.33333333e-05 3.9e-11 3.33333333e-05 4e-11 3.33333333e-05 7.9e-11 3.33333333e-05 8e-11 3.33333333e-05 1.19e-10 3.33333333e-05 1.2e-10 9.99999999e-05 1.59e-10 9.99999999e-05
+ 1.6e-10 3.33333333e-05 1.99e-10 3.33333333e-05 2e-10 -9.99999999e-05 2.39e-10 -9.99999999e-05 2.4e-10 -3.33333333e-05 2.79e-10 -3.33333333e-05 2.8e-10 -9.99999999e-05 3.19e-10 -9.99999999e-05
+ 3.2e-10 9.99999999e-05 3.59e-10 9.99999999e-05 3.6e-10 9.99999999e-05 3.99e-10 9.99999999e-05 4e-10 -9.99999999e-05 4.39e-10 -9.99999999e-05 4.4e-10 3.33333333e-05 4.79e-10 3.33333333e-05
+ 4.8e-10 9.99999999e-05 5.19e-10 9.99999999e-05 5.2e-10 9.99999999e-05 5.59e-10 9.99999999e-05 5.6e-10 -3.33333333e-05 5.99e-10 -3.33333333e-05 6e-10 9.99999999e-05 6.39e-10 9.99999999e-05
+ 6.4e-10 -3.33333333e-05 6.79e-10 -3.33333333e-05 6.8e-10 3.33333333e-05 7.19e-10 3.33333333e-05 7.2e-10 -9.99999999e-05 7.59e-10 -9.99999999e-05 7.6e-10 -9.99999999e-05 7.99e-10 -9.99999999e-05
+ 8e-10 -3.33333333e-05 8.39e-10 -3.33333333e-05 8.4e-10 -3.33333333e-05 8.79e-10 -3.33333333e-05 8.8e-10 3.33333333e-05 9.19e-10 3.33333333e-05 9.2e-10 -3.33333333e-05 9.59e-10 -3.33333333e-05
+ 9.6e-10 -3.33333333e-05 9.99e-10 -3.33333333e-05 1e-09 9.99999999e-05 1.039e-09 9.99999999e-05 1.04e-09 -9.99999999e-05 1.079e-09 -9.99999999e-05 1.08e-09 9.99999999e-05 1.119e-09 9.99999999e-05
+ 1.12e-09 3.33333333e-05 1.159e-09 3.33333333e-05 1.16e-09 -3.33333333e-05 1.199e-09 -3.33333333e-05 1.2e-09 -9.99999999e-05 1.239e-09 -9.99999999e-05 1.24e-09 3.33333333e-05 1.279e-09 3.33333333e-05
+ 1.28e-09 3.33333333e-05 1.319e-09 3.33333333e-05 1.32e-09 3.33333333e-05 1.359e-09 3.33333333e-05 1.36e-09 9.99999999e-05 1.399e-09 9.99999999e-05 1.4e-09 3.33333333e-05 1.439e-09 3.33333333e-05
+ 1.44e-09 -9.99999999e-05 1.479e-09 -9.99999999e-05 1.48e-09 -3.33333333e-05 1.519e-09 -3.33333333e-05 1.52e-09 -9.99999999e-05 1.559e-09 -9.99999999e-05 1.56e-09 9.99999999e-05 1.599e-09 9.99999999e-05
+ 1.6e-09 9.99999999e-05 1.639e-09 9.99999999e-05 1.64e-09 -9.99999999e-05 1.679e-09 -9.99999999e-05 1.68e-09 3.33333333e-05 1.719e-09 3.33333333e-05 1.72e-09 9.99999999e-05 1.759e-09 9.99999999e-05
+ 1.76e-09 9.99999999e-05 1.799e-09 9.99999999e-05 1.8e-09 -3.33333333e-05 1.839e-09 -3.33333333e-05 1.84e-09 9.99999999e-05 1.879e-09 9.99999999e-05 1.88e-09 -3.33333333e-05 1.919e-09 -3.33333333e-05
+ 1.92e-09 3.33333333e-05 1.959e-09 3.33333333e-05 1.96e-09 -9.99999999e-05 1.999e-09 -9.99999999e-05 2e-09 -9.99999999e-05 2.039e-09 -9.99999999e-05 2.04e-09 -3.33333333e-05 2.079e-09 -3.33333333e-05
+ 2.08e-09 -3.33333333e-05 2.119e-09 -3.33333333e-05 2.12e-09 3.33333333e-05 2.159e-09 3.33333333e-05 2.16e-09 -3.33333333e-05 2.199e-09 -3.33333333e-05 2.2e-09 -3.33333333e-05 2.239e-09 -3.33333333e-05
+ 2.24e-09 9.99999999e-05 2.279e-09 9.99999999e-05 2.28e-09 -9.99999999e-05 2.319e-09 -9.99999999e-05 2.32e-09 9.99999999e-05 2.359e-09 9.99999999e-05 2.36e-09 3.33333333e-05 2.399e-09 3.33333333e-05
+ 2.4e-09 -3.33333333e-05 2.439e-09 -3.33333333e-05 2.44e-09 -9.99999999e-05 2.479e-09 -9.99999999e-05 2.48e-09 3.33333333e-05 2.519e-09 3.33333333e-05 2.52e-09 3.33333333e-05 2.559e-09 3.33333333e-05
+ 2.56e-09 3.33333333e-05 2.599e-09 3.33333333e-05 2.6e-09 9.99999999e-05 2.639e-09 9.99999999e-05 2.64e-09 3.33333333e-05 2.679e-09 3.33333333e-05 2.68e-09 -9.99999999e-05 2.719e-09 -9.99999999e-05
+ 2.72e-09 -3.33333333e-05 2.759e-09 -3.33333333e-05 2.76e-09 -9.99999999e-05 2.799e-09 -9.99999999e-05 2.8e-09 9.99999999e-05 2.839e-09 9.99999999e-05 2.84e-09 9.99999999e-05 2.879e-09 9.99999999e-05
+ 2.88e-09 -9.99999999e-05 2.919e-09 -9.99999999e-05 2.92e-09 3.33333333e-05 2.959e-09 3.33333333e-05 2.96e-09 9.99999999e-05 2.999e-09 9.99999999e-05 3e-09 9.99999999e-05 3.039e-09 9.99999999e-05
+ 3.04e-09 -3.33333333e-05 3.079e-09 -3.33333333e-05 3.08e-09 9.99999999e-05 3.119e-09 9.99999999e-05 3.12e-09 -3.33333333e-05 3.159e-09 -3.33333333e-05 3.16e-09 3.33333333e-05 3.199e-09 3.33333333e-05
+ 3.2e-09 -9.99999999e-05 3.239e-09 -9.99999999e-05 3.24e-09 -9.99999999e-05 3.279e-09 -9.99999999e-05 3.28e-09 -3.33333333e-05 3.319e-09 -3.33333333e-05 3.32e-09 -3.33333333e-05 3.359e-09 -3.33333333e-05
+ 3.36e-09 3.33333333e-05 3.399e-09 3.33333333e-05 3.4e-09 -3.33333333e-05 3.439e-09 -3.33333333e-05 3.44e-09 -3.33333333e-05 3.479e-09 -3.33333333e-05 3.48e-09 9.99999999e-05 3.519e-09 9.99999999e-05
+ 3.52e-09 -9.99999999e-05 3.559e-09 -9.99999999e-05 3.56e-09 9.99999999e-05 3.599e-09 9.99999999e-05 3.6e-09 3.33333333e-05 3.639e-09 3.33333333e-05 3.64e-09 -3.33333333e-05 3.679e-09 -3.33333333e-05
+ 3.68e-09 -9.99999999e-05 3.719e-09 -9.99999999e-05 3.72e-09 3.33333333e-05 3.759e-09 3.33333333e-05 3.76e-09 3.33333333e-05 3.799e-09 3.33333333e-05 3.8e-09 3.33333333e-05 3.839e-09 3.33333333e-05
+ 3.84e-09 9.99999999e-05 3.879e-09 9.99999999e-05 3.88e-09 3.33333333e-05 3.919e-09 3.33333333e-05 3.92e-09 -9.99999999e-05 3.959e-09 -9.99999999e-05 3.96e-09 -3.33333333e-05 4e-09 -3.33333333e-05
+ )
I_TB_N inn 0 PWL(
+ 0 3.33333333e-05 3.9e-11 3.33333333e-05 4e-11 3.33333333e-05 7.9e-11 3.33333333e-05 8e-11 3.33333333e-05 1.19e-10 3.33333333e-05 1.2e-10 9.99999999e-05 1.59e-10 9.99999999e-05
+ 1.6e-10 3.33333333e-05 1.99e-10 3.33333333e-05 2e-10 -9.99999999e-05 2.39e-10 -9.99999999e-05 2.4e-10 -3.33333333e-05 2.79e-10 -3.33333333e-05 2.8e-10 -9.99999999e-05 3.19e-10 -9.99999999e-05
+ 3.2e-10 9.99999999e-05 3.59e-10 9.99999999e-05 3.6e-10 9.99999999e-05 3.99e-10 9.99999999e-05 4e-10 -9.99999999e-05 4.39e-10 -9.99999999e-05 4.4e-10 3.33333333e-05 4.79e-10 3.33333333e-05
+ 4.8e-10 9.99999999e-05 5.19e-10 9.99999999e-05 5.2e-10 9.99999999e-05 5.59e-10 9.99999999e-05 5.6e-10 -3.33333333e-05 5.99e-10 -3.33333333e-05 6e-10 9.99999999e-05 6.39e-10 9.99999999e-05
+ 6.4e-10 -3.33333333e-05 6.79e-10 -3.33333333e-05 6.8e-10 3.33333333e-05 7.19e-10 3.33333333e-05 7.2e-10 -9.99999999e-05 7.59e-10 -9.99999999e-05 7.6e-10 -9.99999999e-05 7.99e-10 -9.99999999e-05
+ 8e-10 -3.33333333e-05 8.39e-10 -3.33333333e-05 8.4e-10 -3.33333333e-05 8.79e-10 -3.33333333e-05 8.8e-10 3.33333333e-05 9.19e-10 3.33333333e-05 9.2e-10 -3.33333333e-05 9.59e-10 -3.33333333e-05
+ 9.6e-10 -3.33333333e-05 9.99e-10 -3.33333333e-05 1e-09 9.99999999e-05 1.039e-09 9.99999999e-05 1.04e-09 -9.99999999e-05 1.079e-09 -9.99999999e-05 1.08e-09 9.99999999e-05 1.119e-09 9.99999999e-05
+ 1.12e-09 3.33333333e-05 1.159e-09 3.33333333e-05 1.16e-09 -3.33333333e-05 1.199e-09 -3.33333333e-05 1.2e-09 -9.99999999e-05 1.239e-09 -9.99999999e-05 1.24e-09 3.33333333e-05 1.279e-09 3.33333333e-05
+ 1.28e-09 3.33333333e-05 1.319e-09 3.33333333e-05 1.32e-09 3.33333333e-05 1.359e-09 3.33333333e-05 1.36e-09 9.99999999e-05 1.399e-09 9.99999999e-05 1.4e-09 3.33333333e-05 1.439e-09 3.33333333e-05
+ 1.44e-09 -9.99999999e-05 1.479e-09 -9.99999999e-05 1.48e-09 -3.33333333e-05 1.519e-09 -3.33333333e-05 1.52e-09 -9.99999999e-05 1.559e-09 -9.99999999e-05 1.56e-09 9.99999999e-05 1.599e-09 9.99999999e-05
+ 1.6e-09 9.99999999e-05 1.639e-09 9.99999999e-05 1.64e-09 -9.99999999e-05 1.679e-09 -9.99999999e-05 1.68e-09 3.33333333e-05 1.719e-09 3.33333333e-05 1.72e-09 9.99999999e-05 1.759e-09 9.99999999e-05
+ 1.76e-09 9.99999999e-05 1.799e-09 9.99999999e-05 1.8e-09 -3.33333333e-05 1.839e-09 -3.33333333e-05 1.84e-09 9.99999999e-05 1.879e-09 9.99999999e-05 1.88e-09 -3.33333333e-05 1.919e-09 -3.33333333e-05
+ 1.92e-09 3.33333333e-05 1.959e-09 3.33333333e-05 1.96e-09 -9.99999999e-05 1.999e-09 -9.99999999e-05 2e-09 -9.99999999e-05 2.039e-09 -9.99999999e-05 2.04e-09 -3.33333333e-05 2.079e-09 -3.33333333e-05
+ 2.08e-09 -3.33333333e-05 2.119e-09 -3.33333333e-05 2.12e-09 3.33333333e-05 2.159e-09 3.33333333e-05 2.16e-09 -3.33333333e-05 2.199e-09 -3.33333333e-05 2.2e-09 -3.33333333e-05 2.239e-09 -3.33333333e-05
+ 2.24e-09 9.99999999e-05 2.279e-09 9.99999999e-05 2.28e-09 -9.99999999e-05 2.319e-09 -9.99999999e-05 2.32e-09 9.99999999e-05 2.359e-09 9.99999999e-05 2.36e-09 3.33333333e-05 2.399e-09 3.33333333e-05
+ 2.4e-09 -3.33333333e-05 2.439e-09 -3.33333333e-05 2.44e-09 -9.99999999e-05 2.479e-09 -9.99999999e-05 2.48e-09 3.33333333e-05 2.519e-09 3.33333333e-05 2.52e-09 3.33333333e-05 2.559e-09 3.33333333e-05
+ 2.56e-09 3.33333333e-05 2.599e-09 3.33333333e-05 2.6e-09 9.99999999e-05 2.639e-09 9.99999999e-05 2.64e-09 3.33333333e-05 2.679e-09 3.33333333e-05 2.68e-09 -9.99999999e-05 2.719e-09 -9.99999999e-05
+ 2.72e-09 -3.33333333e-05 2.759e-09 -3.33333333e-05 2.76e-09 -9.99999999e-05 2.799e-09 -9.99999999e-05 2.8e-09 9.99999999e-05 2.839e-09 9.99999999e-05 2.84e-09 9.99999999e-05 2.879e-09 9.99999999e-05
+ 2.88e-09 -9.99999999e-05 2.919e-09 -9.99999999e-05 2.92e-09 3.33333333e-05 2.959e-09 3.33333333e-05 2.96e-09 9.99999999e-05 2.999e-09 9.99999999e-05 3e-09 9.99999999e-05 3.039e-09 9.99999999e-05
+ 3.04e-09 -3.33333333e-05 3.079e-09 -3.33333333e-05 3.08e-09 9.99999999e-05 3.119e-09 9.99999999e-05 3.12e-09 -3.33333333e-05 3.159e-09 -3.33333333e-05 3.16e-09 3.33333333e-05 3.199e-09 3.33333333e-05
+ 3.2e-09 -9.99999999e-05 3.239e-09 -9.99999999e-05 3.24e-09 -9.99999999e-05 3.279e-09 -9.99999999e-05 3.28e-09 -3.33333333e-05 3.319e-09 -3.33333333e-05 3.32e-09 -3.33333333e-05 3.359e-09 -3.33333333e-05
+ 3.36e-09 3.33333333e-05 3.399e-09 3.33333333e-05 3.4e-09 -3.33333333e-05 3.439e-09 -3.33333333e-05 3.44e-09 -3.33333333e-05 3.479e-09 -3.33333333e-05 3.48e-09 9.99999999e-05 3.519e-09 9.99999999e-05
+ 3.52e-09 -9.99999999e-05 3.559e-09 -9.99999999e-05 3.56e-09 9.99999999e-05 3.599e-09 9.99999999e-05 3.6e-09 3.33333333e-05 3.639e-09 3.33333333e-05 3.64e-09 -3.33333333e-05 3.679e-09 -3.33333333e-05
+ 3.68e-09 -9.99999999e-05 3.719e-09 -9.99999999e-05 3.72e-09 3.33333333e-05 3.759e-09 3.33333333e-05 3.76e-09 3.33333333e-05 3.799e-09 3.33333333e-05 3.8e-09 3.33333333e-05 3.839e-09 3.33333333e-05
+ 3.84e-09 9.99999999e-05 3.879e-09 9.99999999e-05 3.88e-09 3.33333333e-05 3.919e-09 3.33333333e-05 3.92e-09 -9.99999999e-05 3.959e-09 -9.99999999e-05 3.96e-09 -3.33333333e-05 4e-09 -3.33333333e-05
+ )
.control
set wr_vecnames
set wr_singlescale
tran 1p 4n 0 1p
wrdata pam4.dat v(finalp) v(finaln)
quit
.endc
.end
