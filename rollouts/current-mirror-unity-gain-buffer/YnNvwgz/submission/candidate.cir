.subckt candidate vinp vinn vout vdd vb1 vb2 vss
* Current-mirror OTA with K=2
* - NMOS diff pair + tail IBIAS
* - PMOS diode loads M3/M4
* - Fold 1:1 (M5/M3) and output source K=2 (M6/M4)
* - NMOS mirror K=2 (M8/M7) to output
* Quiescent current ~2.5*Itail; slew current K*Itail

IBIAS tail vss 152u

M1 d1 vinn tail vss nmos w=100u l=0.4u
M2 d2 vinp  tail vss nmos w=100u l=0.4u

M3 d1  d1  vdd vdd pmos w=10u l=0.4u
M4 d2  d2  vdd vdd pmos w=10u l=0.4u
M5 mid d1  vdd vdd pmos w=10u l=0.4u
M6 vout d2 vdd vdd pmos w=20u l=0.4u

M7 mid  mid vss vss nmos w=6u  l=0.4u
M8 vout mid vss vss nmos w=12u l=0.4u

.ends candidate
