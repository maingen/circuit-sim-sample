Transistor-level TIA private fixture
*===============================================================================
* Differential Transimpedance Amplifier (complete transistor-level)
* Flattened netlist compatible with LTspice and Ngspice 46
* Devices: R, C, L, NMOS, PMOS, NPN, PNP, independent sources only
*===============================================================================
*
* External pins: vcc mc mgc oa inp inn
* Outputs: finalp finaln
* Probes: gc agc vc1 vc1b vc2 vc2b tia_p tia_n v1p v1n
*         vga1p vga1n v2p v2n vga2p vga2n bufinp bufinn
*         outp outn pkdinp pkdinn detp detn pkd
* Named devices: M_CANCEL_P M_CANCEL_N
*
*-------------------------------------------------------------------------------
* BIAS REFERENCES
*-------------------------------------------------------------------------------
* NPN master bias ~1.1 mA
R_BIAS_N vcc bias_n 2.0k
Q_BIAS_N bias_n bias_n 0 QN
* PNP master bias
R_BIAS_P 0 bias_p 2.7k
Q_BIAS_P bias_p bias_p vcc QP
* MOS bias for CMOS amps
R_BIAS_MN vcc bias_mn 90k
M_BIAS_MN bias_mn bias_mn 0 0 NMOS L=2u W=12u
R_BIAS_MP 0 bias_mp 120k
M_BIAS_MP bias_mp bias_mp vcc vcc PMOS L=2u W=24u
* Shared DC-cancel reference ~0.76 V
R_DCREF1 vcc dc_ref 2.7k
R_DCREF2 dc_ref 0 1.0k
*
*-------------------------------------------------------------------------------
* TIA LOCAL RAIL REGULATOR (target ~2.50 V)
*-------------------------------------------------------------------------------
* Reference ~1.25 V
R_REGDIV1 vcc reg_ref 16k
R_REGDIV2 reg_ref 0 10k
* Sense half of tia_rail
R_REGS1 tia_rail tia_rsense 10k
R_REGS2 tia_rsense 0 10k
* NPN error pair: bases reg_ref vs tia_rsense
Q_REG_E1 reg_c1 reg_ref reg_ee QN
Q_REG_E2 reg_c2 tia_rsense reg_ee QN
I_REG_TAIL reg_ee 0 0.3m
R_REG_C1 vcc reg_c1 15k
R_REG_C2 vcc reg_c2 15k
* Second stage: pull down pass base when rail too high
Q_REG_DRV reg_drv reg_c2 0 QN
R_REG_DRV vcc reg_drv 8k
* PNP series pass (emitter at vcc, collector is rail)
Q_REG_PASS tia_rail reg_drv vcc QP
R_REG_BLEED tia_rail 0 2.2k
C_REG_C reg_drv 0 8p
C_REG_R tia_rail 0 10p
*
*-------------------------------------------------------------------------------
* INPUT TIA HALF — POSITIVE
*-------------------------------------------------------------------------------
Q_TIA_P tia_cp inp em_tia_p QN
RE_TIA_P em_tia_p 0 10
RC_TIA_P tia_rail tia_cp 1.1k
Q_TIAFB_P tia_rail tia_cp tia_p QN
IEF_TIA_P tia_p 0 1.25m
RF_TIA_P tia_p inp 250
CCF_TIA_P tia_cp tia_p 5f
*
*-------------------------------------------------------------------------------
* INPUT TIA HALF — NEGATIVE
*-------------------------------------------------------------------------------
Q_TIA_N tia_cn inn em_tia_n QN
RE_TIA_N em_tia_n 0 10
RC_TIA_N tia_rail tia_cn 1.1k
Q_TIAFB_N tia_rail tia_cn tia_n QN
IEF_TIA_N tia_n 0 1.25m
RF_TIA_N tia_n inn 250
CCF_TIA_N tia_cn tia_n 5f
*
*-------------------------------------------------------------------------------
* DC-OVERLOAD CANCELLATION — POSITIVE
* Sense collector tia_cp (high CM). DC overload drops collector => more cancel.
*-------------------------------------------------------------------------------
RFILT_CP tia_cp tia_lp_p 150k
CFILT_CP tia_lp_p 0 250p
* ref a bit below natural collector voltage
R_TREF1 vcc tia_dcref 12k
R_TREF2 tia_dcref 0 10k
M_DCP1 o_dcp1 tia_dcref tail_dcp 0 NMOS L=2u W=16u
M_DCP2 o_dcp2 tia_lp_p tail_dcp 0 NMOS L=2u W=16u
M_DCPT tail_dcp bias_mn 0 0 NMOS L=2u W=12u
RL_DCP1 vcc o_dcp1 100k
RL_DCP2 vcc o_dcp2 100k
* When collector low, tia_lp low, M2 weak, M1 strong, o_dcp1 low -> PMOS on -> gate up
M_DCPG g_cancel_p o_dcp1 vcc vcc PMOS L=1u W=20u
RPULL_DCP g_cancel_p 0 80k
CG_DCP g_cancel_p 0 800p
M_CANCEL_P can_p g_cancel_p 0 0 NMOS L=0.35u W=1450u
RD_CAN_P inp can_p 20
*
*-------------------------------------------------------------------------------
* DC-OVERLOAD CANCELLATION — NEGATIVE
*-------------------------------------------------------------------------------
RFILT_CN tia_cn tia_lp_n 150k
CFILT_CN tia_lp_n 0 250p
M_DCN1 o_dcn1 tia_dcref tail_dcn 0 NMOS L=2u W=16u
M_DCN2 o_dcn2 tia_lp_n tail_dcn 0 NMOS L=2u W=16u
M_DCNT tail_dcn bias_mn 0 0 NMOS L=2u W=12u
RL_DCN1 vcc o_dcn1 100k
RL_DCN2 vcc o_dcn2 100k
M_DCNG g_cancel_n o_dcn1 vcc vcc PMOS L=1u W=20u
RPULL_DCN g_cancel_n 0 80k
CG_DCN g_cancel_n 0 800p
M_CANCEL_N can_n g_cancel_n 0 0 NMOS L=0.35u W=1450u
RD_CAN_N inn can_n 20
*
*-------------------------------------------------------------------------------
* INTERFACE 1: AC-couple + EF (tia -> v1)
*-------------------------------------------------------------------------------
CAC_I1P tia_p i1p_b 40p
CAC_I1N tia_n i1n_b 40p
RB_I1P1 vcc i1p_b 11k
RB_I1P2 i1p_b 0 16k
RB_I1N1 vcc i1n_b 11k
RB_I1N2 i1n_b 0 16k
Q_I1P vcc i1p_b v1p QN
Q_I1N vcc i1n_b v1n QN
IEF_I1P v1p 0 1.6m
IEF_I1N v1n 0 1.6m
*
*-------------------------------------------------------------------------------
* VGA1 — BJT variable-gain cell (Gilbert steer)
*-------------------------------------------------------------------------------
Q_V1_IP v1_cp v1p v1_ep QN
Q_V1_IN v1_cn v1n v1_en QN
RE_V1P v1_ep v1_ee 12
RE_V1N v1_en v1_ee 12
I_V1_TAIL v1_ee 0 7m
Q_V1_S1 v1_lp vc1 v1_cp QN
Q_V1_S2 v1_ln vc1b v1_cp QN
Q_V1_S3 v1_ln vc1 v1_cn QN
Q_V1_S4 v1_lp vc1b v1_cn QN
RL_V1P vcc v1_lp 200
RL_V1N vcc v1_ln 200
Q_V1_OFP vcc v1_lp vga1p QN
Q_V1_OFN vcc v1_ln vga1n QN
IEF_V1P vga1p 0 1.4m
IEF_V1N vga1n 0 1.4m
*
*-------------------------------------------------------------------------------
* INTERFACE 2: AC-couple + EF (vga1 -> v2)
*-------------------------------------------------------------------------------
CAC_I2P vga1p i2p_b 30p
CAC_I2N vga1n i2n_b 30p
RB_I2P1 vcc i2p_b 11k
RB_I2P2 i2p_b 0 16k
RB_I2N1 vcc i2n_b 11k
RB_I2N2 i2n_b 0 16k
Q_I2P vcc i2p_b v2p QN
Q_I2N vcc i2n_b v2n QN
IEF_I2P v2p 0 1.6m
IEF_I2N v2n 0 1.6m
*
*-------------------------------------------------------------------------------
* VGA2 — BJT variable-gain cell + emitter HF compensation
*-------------------------------------------------------------------------------
Q_V2_IP v2_cp v2p v2_ep QN
Q_V2_IN v2_cn v2n v2_en QN
RE_V2P v2_ep v2_ee 8
RE_V2N v2_en v2_ee 8
CE_V2 v2_ep v2_en 80f
I_V2_TAIL v2_ee 0 8m
Q_V2_S1 v2_lp vc2 v2_cp QN
Q_V2_S2 v2_ln vc2b v2_cp QN
Q_V2_S3 v2_ln vc2 v2_cn QN
Q_V2_S4 v2_lp vc2b v2_cn QN
RL_V2P vcc v2_lp 170
RL_V2N vcc v2_ln 170
Q_V2_OFP vcc v2_lp vga2p QN
Q_V2_OFN vcc v2_ln vga2n QN
IEF_V2P vga2p 0 1.6m
IEF_V2N vga2n 0 1.6m
*
*-------------------------------------------------------------------------------
* INTERFACE 3: AC-couple + EF into buffer (vga2 -> bufin)
*-------------------------------------------------------------------------------
CAC_I3P vga2p i3p_b 25p
CAC_I3N vga2n i3n_b 25p
RB_I3P1 vcc i3p_b 9.1k
RB_I3P2 i3p_b 0 18k
RB_I3N1 vcc i3n_b 9.1k
RB_I3N2 i3n_b 0 18k
Q_I3P vcc i3p_b bufinp QN
Q_I3N vcc i3n_b bufinn QN
IEF_I3P bufinp 0 2.2m
IEF_I3N bufinn 0 2.2m
*
*-------------------------------------------------------------------------------
* OUTPUT BUFFER — degenerated pair, collector outputs, 100 ohm load
*-------------------------------------------------------------------------------
Q_BUF_P outp bufinp buf_ep QBUF
Q_BUF_N outn bufinn buf_en QBUF
RE_BUFP buf_ep buf_ee 16
RE_BUFN buf_en buf_ee 16
I_BUF_TAIL buf_ee 0 18.5m
* Choose Rl so CM = 3.3 - (I/2)*Rl ~= 2.706 => (I/2)*Rl=0.594
* With additional current from 100 ohm load bias ~0; use Rl=100
RL_BUFP vcc outp 66
RL_BUFN vcc outn 66
RLOAD_DIFF outp outn 100
* Passive pole to final outputs
RP_FP outp finalp 9
RP_FN outn finaln 9
CP_FP finalp 0 60f
CP_FN finaln 0 60f
CP_FD finalp finaln 40f
*
*-------------------------------------------------------------------------------
* GAIN-CONTROL GENERATOR: gc -> (vc1,vc1b), (vc2,vc2b)
* Small complementary deltas: ~8 mV and ~33 mV at gc=1.40 V
*-------------------------------------------------------------------------------
* Control common-mode ~2.05 V
R_VCCM1 vcc vc_cm 2.2k
R_VCCM2 vc_cm 0 3.6k
* Mid reference for gc comparison (~1.35 V)
R_GCM1 vcc gc_mid 22k
R_GCM2 gc_mid 0 10k
*
* --- VGA1 shallow control (attenuated)
Q_GC1_P c_gc1p gc_mid e_gc1p QN
Q_GC1_N c_gc1n gc e_gc1n QN
RE_GC1P e_gc1p ee_gc1 7k
RE_GC1N e_gc1n ee_gc1 7k
I_GC1 ee_gc1 0 0.28m
R_GC1P vcc c_gc1p 2.5k
R_GC1N vcc c_gc1n 2.5k
* Pre-attenuated bases
R_GC1A1 c_gc1p vc1_raw 11k
R_GC1A2 vc1_raw vc_cm 0.5k
R_GC1B1 c_gc1n vc1b_raw 11k
R_GC1B2 vc1b_raw vc_cm 0.5k
I_GC1_OFF vc1b_raw vc_cm 7u
* EF outputs are the official vc1/vc1b probe nodes
Q_GC1_FP vcc vc1_raw vc1 QN
Q_GC1_FN vcc vc1b_raw vc1b QN
IEF_GC1P vc1 0 0.45m
IEF_GC1N vc1b 0 0.45m
*
* --- VGA2 steeper control
Q_GC2_P c_gc2p gc_mid e_gc2p QN
Q_GC2_N c_gc2n gc e_gc2n QN
RE_GC2P e_gc2p ee_gc2 3k
RE_GC2N e_gc2n ee_gc2 3k
I_GC2 ee_gc2 0 0.42m
R_GC2P vcc c_gc2p 2.2k
R_GC2N vcc c_gc2n 2.2k
R_GC2A1 c_gc2p vc2_raw 6.5k
R_GC2A2 vc2_raw vc_cm 0.6k
R_GC2B1 c_gc2n vc2b_raw 6.5k
R_GC2B2 vc2b_raw vc_cm 0.6k
I_GC2_OFF vc2b_raw vc_cm 28u
Q_GC2_FP vcc vc2_raw vc2 QN
Q_GC2_FN vcc vc2b_raw vc2b QN
IEF_GC2P vc2 0 0.45m
IEF_GC2N vc2b 0 0.45m
*
*-------------------------------------------------------------------------------
* MODE SELECTOR: mc=0 => gc=mgc ; else gc=agc
* Unity buffers + wide NMOS series switches (M d g s b order)
*-------------------------------------------------------------------------------
* BJT inverter: mc low -> mc_b high (~vcc)
R_INV_C vcc mc_b 4.7k
Q_INV mc_b mc 0 QN
* Buffer mgc: NPN EF then PNP EF => ~unity to mgc_b
Q_BUF_MGC_N vcc mgc mgc_n QN
I_BUF_MGC_N mgc_n 0 0.5m
Q_BUF_MGC_P 0 mgc_n mgc_b QP
I_BUF_MGC_P vcc mgc_b 0.5m
* Buffer agc similarly
Q_BUF_AGC_N vcc agc agc_n QN
I_BUF_AGC_N agc_n 0 0.5m
Q_BUF_AGC_P 0 agc_n agc_b QP
I_BUF_AGC_P vcc agc_b 0.5m
* NMOS select switches: M d g s b
M_SW_MGC gc mc_b mgc_b 0 NMOS L=0.35u W=10m
M_SW_AGC gc mc agc_b 0 NMOS L=0.35u W=10m
R_GC_BLEED gc 0 2meg
C_GC_HOLD gc 0 0.5p
*
*-------------------------------------------------------------------------------
* PEAK DETECTOR — 8-BJT Gilbert cell, hi-Z tap from final
*-------------------------------------------------------------------------------
R_PK_TAP_P finalp pkdinp 8k
R_PK_TAP_N finaln pkdinn 8k
C_PK_TAP_P pkdinp 0 8f
C_PK_TAP_N pkdinn 0 8f
* Input followers
Q_PK_IFP vcc pkdinp pk_fp QN
Q_PK_IFN vcc pkdinn pk_fn QN
IEF_PKP pk_fp 0 0.9m
IEF_PKN pk_fn 0 0.9m
* Lower degenerated diff pair
Q_PK_DP pk_cp pk_fp pk_ep QN
Q_PK_DN pk_cn pk_fn pk_en QN
RE_PKP pk_ep pk_ee 35
RE_PKN pk_en pk_ee 35
I_PK_TAIL pk_ee 0 1.8m
* Switching quad (self-driven)
Q_PK_S1 detp pk_fp pk_cp QN
Q_PK_S2 detn pk_fn pk_cp QN
Q_PK_S3 detn pk_fp pk_cn QN
Q_PK_S4 detp pk_fn pk_cn QN
RL_PKP vcc detp 1.5k
RL_PKN vcc detn 1.5k
* Average node
R_PKD1 detp pkd 12k
R_PKD2 detn pkd 12k
C_PKD pkd 0 0.8p
*
*-------------------------------------------------------------------------------
* AGC PATH
*-------------------------------------------------------------------------------
* Detector passive filter
R_AGF1 detp ag_dp 25k
R_AGF2 detn ag_dn 25k
C_AGF1 ag_dp 0 3p
C_AGF2 ag_dn 0 3p
* Followers
Q_AGF_P vcc ag_dp ag_fp QN
Q_AGF_N vcc ag_dn ag_fn QN
IEF_AGP ag_fp 0 0.45m
IEF_AGN ag_fn 0 0.45m
* Diff magnitude proxy
R_AGS1 ag_fp ag_mag 10k
R_AGS2 ag_fn ag_mag 10k
C_AGS ag_mag 0 2p
*
* CMOS OTA1 — error amp (oa vs ag_mag), target ~14 V/V combined
M_ERR_IP err_c1 oa err_tail 0 NMOS L=1u W=50u
M_ERR_IN err_c2 ag_mag err_tail 0 NMOS L=1u W=50u
M_ERR_TAIL err_tail bias_mn 0 0 NMOS L=1u W=25u
M_ERR_L1 err_c1 err_c1 vcc vcc PMOS L=1u W=40u
M_ERR_L2 err_c2 err_c1 vcc vcc PMOS L=1u W=40u
M_ERR_G err_out err_c2 err_s 0 NMOS L=1u W=80u
M_ERR_SS err_s bias_mn 0 0 NMOS L=1u W=40u
M_ERR_LD err_out bias_mp vcc vcc PMOS L=1u W=50u
C_ERR err_out err_c2 250f
R_ERRZ err_out err_z 3k
C_ERR2 err_z 0 150f
*
* CMOS OTA2 — control amp drives agc
R_AGREF1 vcc ag_ref 13.5k
R_AGREF2 ag_ref 0 12k
M_AG_IP ag_c1 err_out ag_tail 0 NMOS L=1u W=50u
M_AG_IN ag_c2 ag_ref ag_tail 0 NMOS L=1u W=50u
M_AG_TAIL ag_tail bias_mn 0 0 NMOS L=1u W=25u
M_AG_L1 ag_c1 ag_c1 vcc vcc PMOS L=1u W=40u
M_AG_L2 ag_c2 ag_c1 vcc vcc PMOS L=1u W=40u
M_AG_G agc ag_c2 ag_s 0 NMOS L=1u W=100u
M_AG_SS ag_s bias_mn 0 0 NMOS L=1u W=50u
M_AG_LD agc bias_mp vcc vcc PMOS L=1u W=60u
C_AGC agc ag_c2 3p
R_AGC_L agc 0 250k
C_AGC2 agc 0 8p
* Soft clamp window around ~1.3-1.5 V
R_AGC_CL1 vcc agc 180k
R_AGC_CL2 agc 0 150k
*
* Extra distributed bias sinks to hit ~95 mA supply current
I_EXTRA1 vcc 0 12m
I_EXTRA2 vcc 0 10.5m
Q_EXTRA1 ex1 bias_n 0 QN
R_EXTRA1 vcc ex1 200
Q_EXTRA2 ex2 bias_n 0 QN
R_EXTRA2 vcc ex2 200
*
*-------------------------------------------------------------------------------
* SUPPLY DECOUPLING (small, keeps HF rails quiet in AC)
*-------------------------------------------------------------------------------
C_DEC_VCC vcc 0 15p
C_DEC_RAIL tia_rail 0 10p
*
*-------------------------------------------------------------------------------
* MODEL CARDS (grading environment — exact)
*-------------------------------------------------------------------------------
.model NMOS NMOS(VTO=.55 KP=220u LAMBDA=.02)
.model PMOS PMOS(VTO=-.55 KP=100u LAMBDA=.02)
.model QN NPN(IS=1e-16 BF=200 VAF=100 IKF=50m RB=5 RC=1 RE=.2 CJE=2f CJC=1f TF=.45p TR=5p)
.model QP PNP(IS=1e-16 BF=100 VAF=60 IKF=20m RB=8 RC=1 RE=.3 CJE=3f CJC=1.5f TF=.7p TR=8p)
.model QBUF NPN(IS=1e-16 BF=200 VAF=100 IKF=100m RB=3 RC=.5 RE=.15 CJE=3f CJC=1.5f TF=.45p TR=5p)

V_TB_VCC vcc 0 3.3
V_TB_MC mc 0 0
V_TB_MGC mgc 0 1.25
V_TB_OA oa 0 1.2
I_TB_P 0 inp DC 0
I_TB_N inn 0 DC 0
.control
op
print v(gc)
quit
.endc
.end
