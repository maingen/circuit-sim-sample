Transistor-level TIA private fixture
* Complete transistor-level differential TIA + dual VGA + AGC
* Flattened netlist for LTspice / Ngspice-46 (circuit only)
* External: vcc mc mgc oa inp inn finalp finaln
* Probes: gc agc vc1 vc1b vc2 vc2b tia_p tia_n v1p v1n
*         vga1p vga1n v2p v2n vga2p vga2n bufinp bufinn
*         outp outn pkdinp pkdinn detp detn pkd
* Cancel sinks: M_CANCEL_P M_CANCEL_N

* ============================================================================
* BIAS
* ============================================================================
* Master NPN reference with classic beta-helper (base current bootstrapped)
* Q_IREF senses Iref; Q_IHELP feeds the shared base bus ntail/ntailb
Q_IREF iref_c ntail 0 QN
R_IREF vcc iref_c 2.55k
Q_IHELP vcc iref_c ntail QN
R_IHELP_BLEED ntail 0 25k
* Second helper for QBUF bus (same base voltage)
Q_IHELPB vcc iref_c ntailb QBUF
R_IHELPB_BLEED ntailb 0 20k
R_BMIR ntail ntailb 50
* Alias probe node iref to base bus for readability
R_IREF_ALIAS ntail iref 1m

* Fixed dividers
R_BCAS1 vcc bcas 11k
R_BCAS2 bcas 0 9k
C_BCAS bcas 0 0.5p

* Interface base CM ~2.75 V so EF emitters land near 1.95 V
R_BCM1 vcc bcm 2.0k
R_BCM2 bcm 0 10k
C_BCM bcm 0 1p

R_BST1 vcc bsteer 6.2k
R_BST2 bsteer 0 10k
C_BST bsteer 0 0.5p

* Vbe ref for DC-cancel — matched to TIA CE natural Vbe
Q_VBER vbe_ref vbe_ref 0 QN
R_VBER vcc vbe_ref 2.70k

* MOS bias
M_NBD nbias nbias 0 0 NMOS W=8u L=1u
R_NBD vcc nbias 90k
M_PBD pbias pbias vcc vcc PMOS W=16u L=1u
R_PBD pbias 0 120k

* ============================================================================
* TIA LOCAL RAIL (shunt Vbe-multiplier regulator ~2.55 V)
* ============================================================================
R_TREG_S vcc vtia_rail 55
R_TREG_1 vtia_rail treg_fb 12k
R_TREG_2 treg_fb 0 8.2k
Q_TREG vtia_rail treg_fb 0 QN
C_TREG vtia_rail 0 4p

* ============================================================================
* INPUT TIA P (inp -> tia_p)
* CE + shunt Rf via EF feedback, local rail, DC cancel
* ============================================================================
Q_TIA_CE_P tia_col_p inp 0 QN
R_TIA_LP vtia_rail tia_cxp 1.45k
L_TIA_LP tia_cxp tia_col_p 120p
Q_TIA_FP vcc tia_col_p tia_p QN
Q_TIA_FSP tia_p ntail 0 QN
R_TIA_FEP tia_p 0 5.5k
R_TIA_FBP tia_p inp 230
C_TIA_ZP tia_p inp 8f

* DC-overload cancel P: high-gain CMOS integrator servo to vbe_ref
R_DCP_IN inp dcp_fil 150k
C_DCP_IN dcp_fil 0 300p
R_DCP_RF vbe_ref dcp_ref 150k
C_DCP_RF dcp_ref 0 300p
M_DCP_IP dcp_c dcp_ref dcp_t 0 NMOS W=12u L=2u
M_DCP_IN dcp_d dcp_fil dcp_t 0 NMOS W=12u L=2u
M_DCP_TL dcp_t nbias 0 0 NMOS W=12u L=2u
M_DCP_L1 dcp_c dcp_c vcc vcc PMOS W=24u L=2u
M_DCP_L2 dcp_d dcp_c vcc vcc PMOS W=24u L=2u
* Folded second stage to cancel_gp (inverting): dcp_d low => gate high
M_DCP_P2 cancel_gp dcp_d vcc vcc PMOS W=80u L=0.8u
M_DCP_N2 cancel_gp nbias 0 0 NMOS W=15u L=0.8u
C_DCP_INT dcp_d cancel_gp 80p
R_DCP_Z dcp_d dcp_z 2k
C_DCP_Z dcp_z cancel_gp 20p
C_DCP_G cancel_gp 0 200p
M_CANCEL_P inp cancel_gp 0 0 NMOS W=250u L=0.5u

* ============================================================================
* INPUT TIA N (inn -> tia_n)
* ============================================================================
Q_TIA_CE_N tia_col_n inn 0 QN
R_TIA_LN vtia_rail tia_cxn 1.45k
L_TIA_LN tia_cxn tia_col_n 120p
Q_TIA_FN vcc tia_col_n tia_n QN
Q_TIA_FSN tia_n ntail 0 QN
R_TIA_FEN tia_n 0 5.5k
R_TIA_FBN tia_n inn 230
C_TIA_ZN tia_n inn 8f

R_DCN_IN inn dcn_fil 150k
C_DCN_IN dcn_fil 0 300p
R_DCN_RF vbe_ref dcn_ref 150k
C_DCN_RF dcn_ref 0 300p
M_DCN_IP dcn_c dcn_ref dcn_t 0 NMOS W=12u L=2u
M_DCN_IN dcn_d dcn_fil dcn_t 0 NMOS W=12u L=2u
M_DCN_TL dcn_t nbias 0 0 NMOS W=12u L=2u
M_DCN_L1 dcn_c dcn_c vcc vcc PMOS W=24u L=2u
M_DCN_L2 dcn_d dcn_c vcc vcc PMOS W=24u L=2u
M_DCN_P2 cancel_gn dcn_d vcc vcc PMOS W=80u L=0.8u
M_DCN_N2 cancel_gn nbias 0 0 NMOS W=15u L=0.8u
C_DCN_INT dcn_d cancel_gn 80p
R_DCN_Z dcn_d dcn_z 2k
C_DCN_Z dcn_z cancel_gn 20p
C_DCN_G cancel_gn 0 200p
M_CANCEL_N inn cancel_gn 0 0 NMOS W=250u L=0.5u

* ============================================================================
* INTERFACE 1 (AC + EF) tia -> v1
* ============================================================================
C_IF1P tia_p if1p 20p
C_IF1N tia_n if1n 20p
R_IF1P if1p bcm 8k
R_IF1N if1n bcm 8k
Q_IF1P vcc if1p v1p QN
Q_IF1N vcc if1n v1n QN
Q_IF1SP v1p ntail 0 QN
Q_IF1SN v1n ntail 0 QN
Q_IF1SP2 v1p ntail 0 QN
Q_IF1SN2 v1n ntail 0 QN
R_IF1EP v1p 0 2.2k
R_IF1EN v1n 0 2.2k

* ============================================================================
* VGA1: degenerated diff pair + steering quad + loads + EF
* ============================================================================
* Input pair (collectors feed steering emitters)
Q_VGA1_IP e1p v1p ee1p QN
Q_VGA1_IN e1n v1n ee1n QN
R_VGA1_DP ee1p t1 16
R_VGA1_DN ee1n t1 16
Q_VGA1_T1 t1 ntail 0 QN
Q_VGA1_T2 t1 ntail 0 QN
Q_VGA1_T3 t1 ntail 0 QN
Q_VGA1_T4 t1 ntail 0 QN
Q_VGA1_T5 t1 ntail 0 QN

* Steering quad: at mgc=1.40, vc1b > vc1 so vc1b drives signal collectors
Q_VGA1_S1 c1p vc1b e1p QN
Q_VGA1_S2 vcc vc1 e1p QN
Q_VGA1_S3 c1n vc1b e1n QN
Q_VGA1_S4 vcc vc1 e1n QN

R_VGA1_LP vcc c1px 135
R_VGA1_LN vcc c1nx 135
L_VGA1_LP c1px c1p 100p
L_VGA1_LN c1nx c1n 100p
C_VGA1_C c1p c1n 10f

Q_VGA1_FP vcc c1p vga1p QN
Q_VGA1_FN vcc c1n vga1n QN
Q_VGA1_FSP vga1p ntail 0 QN
Q_VGA1_FSN vga1n ntail 0 QN
R_VGA1_RP vga1p 0 2.2k
R_VGA1_RN vga1n 0 2.2k

* ============================================================================
* INTERFACE 2
* ============================================================================
C_IF2P vga1p if2p 20p
C_IF2N vga1n if2n 20p
R_IF2P if2p bcm 8k
R_IF2N if2n bcm 8k
Q_IF2P vcc if2p v2p QN
Q_IF2N vcc if2n v2n QN
Q_IF2SP v2p ntail 0 QN
Q_IF2SN v2n ntail 0 QN
Q_IF2SP2 v2p ntail 0 QN
Q_IF2SN2 v2n ntail 0 QN
R_IF2EP v2p 0 2.2k
R_IF2EN v2n 0 2.2k

* ============================================================================
* VGA2: degenerated pair + steering + HF emitter cap compensation
* ============================================================================
Q_VGA2_IP e2p v2p ee2p QN
Q_VGA2_IN e2n v2n ee2n QN
R_VGA2_DP ee2p t2 18
R_VGA2_DN ee2n t2 18
C_VGA2_Z ee2p ee2n 120f
Q_VGA2_T1 t2 ntail 0 QN
Q_VGA2_T2 t2 ntail 0 QN
Q_VGA2_T3 t2 ntail 0 QN
Q_VGA2_T4 t2 ntail 0 QN
Q_VGA2_T5 t2 ntail 0 QN

Q_VGA2_S1 c2p vc2b e2p QN
Q_VGA2_S2 vcc vc2 e2p QN
Q_VGA2_S3 c2n vc2b e2n QN
Q_VGA2_S4 vcc vc2 e2n QN

R_VGA2_LP vcc c2px 145
R_VGA2_LN vcc c2nx 145
L_VGA2_LP c2px c2p 90p
L_VGA2_LN c2nx c2n 90p
C_VGA2_C c2p c2n 10f

Q_VGA2_FP vcc c2p vga2p QN
Q_VGA2_FN vcc c2n vga2n QN
Q_VGA2_FSP vga2p ntail 0 QN
Q_VGA2_FSN vga2n ntail 0 QN
R_VGA2_RP vga2p 0 2.2k
R_VGA2_RN vga2n 0 2.2k

* ============================================================================
* INTERFACE 3 -> bufinp/bufinn
* ============================================================================
C_IF3P vga2p if3p 20p
C_IF3N vga2n if3n 20p
R_IF3P if3p bcm 8k
R_IF3N if3n bcm 8k
Q_IF3P vcc if3p bufinp QN
Q_IF3N vcc if3n bufinn QN
Q_IF3SP bufinp ntailb 0 QBUF
Q_IF3SN bufinn ntailb 0 QBUF
Q_IF3SP2 bufinp ntailb 0 QBUF
Q_IF3SN2 bufinn ntailb 0 QBUF
R_IF3EP bufinp 0 1.6k
R_IF3EN bufinn 0 1.6k

* ============================================================================
* OUTPUT BUFFER (gain ~3.5 dB, Vcm~2.7 V, 100 ohm load)
* Degenerated BJT pair, resistive loads, 100 ohm diff load, no cascode
* ============================================================================
Q_BUF_IP outn bufinp ebufp QBUF
Q_BUF_IN outp bufinn ebufn QBUF
R_BUF_DP ebufp bt 14
R_BUF_DN ebufn bt 14
Q_BUF_T1 bt ntailb 0 QBUF
Q_BUF_T2 bt ntailb 0 QBUF
Q_BUF_T3 bt ntailb 0 QBUF
Q_BUF_T4 bt ntailb 0 QBUF
Q_BUF_T5 bt ntailb 0 QBUF
Q_BUF_T6 bt ntailb 0 QBUF
Q_BUF_T7 bt ntailb 0 QBUF
Q_BUF_T8 bt ntailb 0 QBUF
Q_BUF_T9 bt ntailb 0 QBUF
Q_BUF_T10 bt ntailb 0 QBUF
Q_BUF_T11 bt ntailb 0 QBUF
Q_BUF_T12 bt ntailb 0 QBUF
Q_BUF_T13 bt ntailb 0 QBUF
Q_BUF_T14 bt ntailb 0 QBUF
Q_BUF_T15 bt ntailb 0 QBUF
Q_BUF_T16 bt ntailb 0 QBUF
Q_BUF_T17 bt ntailb 0 QBUF
Q_BUF_T18 bt ntailb 0 QBUF
Q_BUF_T19 bt ntailb 0 QBUF
Q_BUF_T20 bt ntailb 0 QBUF
Q_BUF_T21 bt ntailb 0 QBUF

R_BUF_LP vcc outnx 50
R_BUF_LN vcc outpx 50
L_BUF_LP outnx outn 55p
L_BUF_LN outpx outp 55p
R_BUF_LD outp outn 100
C_BUF_LD outp outn 18f

R_POLE_P outp finalp 14
R_POLE_N outn finaln 14
C_POLE_P finalp 0 42f
C_POLE_N finaln 0 42f
C_POLE_D finalp finaln 28f

* ============================================================================
* GAIN CONTROL GEN: gc -> vc1/vc1b (shallow), vc2/vc2b (steep)
* Centered so gc=1.40 gives few-mV differentials
* ============================================================================
* Reference near ~1.32 V so gc=1.25..1.40 spans useful steering range
R_GCR1 vcc gcref 15.0k
R_GCR2 gcref 0 10k

* Sense dividers (matched attenuation)
R_GCS1 gc gcs 8k
R_GCS2 gcs 0 8k
R_GCRH1 gcref gcrh 8k
R_GCRH2 gcrh 0 8k

* VGA1 control pair (low gm) — target |dvc1|~8 mV at gc=1.40
Q_GC1_IP gc1a gcs gc1e QN
Q_GC1_IN gc1b gcrh gc1e QN
R_GC1_EE gc1e gc1t 450
Q_GC1_T gc1t ntail 0 QN
R_GC1_LA vcc gc1a 1.8k
R_GC1_LB vcc gc1b 1.8k
Q_GC1_FA vcc gc1a gc1fa QN
Q_GC1_FB vcc gc1b gc1fb QN
R_GC1_FA gc1fa 0 12k
R_GC1_FB gc1fb 0 12k
R_VC1_A gc1fa vc1 4k
R_VC1_B bsteer vc1 4k
R_VC1B_A gc1fb vc1b 4k
R_VC1B_B bsteer vc1b 4k
C_VC1 vc1 0 0.15p
C_VC1B vc1b 0 0.15p

* VGA2 control pair (higher gm / gain) — target |dvc2|~33 mV at gc=1.40
Q_GC2_IP gc2a gcs gc2e QN
Q_GC2_IN gc2b gcrh gc2e QN
R_GC2_EE gc2e gc2t 90
Q_GC2_T gc2t ntail 0 QN
Q_GC2_T2 gc2t ntail 0 QN
R_GC2_LA vcc gc2a 4.5k
R_GC2_LB vcc gc2b 4.5k
Q_GC2_FA vcc gc2a gc2fa QN
Q_GC2_FB vcc gc2b gc2fb QN
R_GC2_FA gc2fa 0 10k
R_GC2_FB gc2fb 0 10k
R_VC2_A gc2fa vc2 2.5k
R_VC2_B bsteer vc2 2.5k
R_VC2B_A gc2fb vc2b 2.5k
R_VC2B_B bsteer vc2b 2.5k
C_VC2 vc2 0 0.15p
C_VC2B vc2b 0 0.15p

* ============================================================================
* MODE SELECT: mc=0 -> gc=mgc; else gc=agc
* ============================================================================
M_MCINV_N mcb mc 0 0 NMOS W=4u L=0.5u
M_MCINV_P mcb mc vcc vcc PMOS W=8u L=0.5u
R_MCINV mcb vcc 250k

M_TG1_N mgc mcb gc 0 NMOS W=30u L=0.5u
M_TG1_P mgc mc gc vcc PMOS W=60u L=0.5u
M_TG2_N agc mc gc 0 NMOS W=30u L=0.5u
M_TG2_P agc mcb gc vcc PMOS W=60u L=0.5u
C_GC gc 0 0.2p

* ============================================================================
* PEAK DETECTOR (8-BJT Gilbert) high-Z tap from final
* ============================================================================
R_PKD_TP finalp pkdinp 10k
R_PKD_TN finaln pkdinn 10k
C_PKD_CP pkdinp 0 8f
C_PKD_CN pkdinn 0 8f

Q_PKD_FP vcc pkdinp pk_fp QN
Q_PKD_FN vcc pkdinn pk_fn QN
R_PKD_EP pk_fp 0 6k
R_PKD_EN pk_fn 0 6k
Q_PKD_SP pk_fp ntail 0 QN
Q_PKD_SN pk_fn ntail 0 QN

Q_PKD_IP pk_a pk_fp pk_t QN
Q_PKD_IN pk_b pk_fn pk_t QN
R_PKD_DEG pk_a pk_b 90
Q_PKD_TT1 pk_t ntail 0 QN
Q_PKD_TT2 pk_t ntail 0 QN

Q_PKD_Q1 detn pk_fp pk_a QN
Q_PKD_Q2 detp pk_fn pk_a QN
Q_PKD_Q3 detp pk_fp pk_b QN
Q_PKD_Q4 detn pk_fn pk_b QN

R_PKD_LP vcc detp 1.05k
R_PKD_LN vcc detn 1.05k
C_PKD_LP detp 0 0.8p
C_PKD_LN detn 0 0.8p
C_PKD_LD detp detn 0.4p

R_PKD_S1 detp pkd 12k
R_PKD_S2 detn pkd 12k
C_PKD_S pkd 0 2p

* ============================================================================
* AGC PATH (CMOS two-opamp servo) -> agc
* ============================================================================
R_AGC_F1 detp agc_fp 6k
R_AGC_F2 detn agc_fn 6k
C_AGC_F1 agc_fp 0 4p
C_AGC_F2 agc_fn 0 4p
Q_AGC_FP vcc agc_fp agc_ep QN
Q_AGC_FN vcc agc_fn agc_en QN
R_AGC_EP agc_ep 0 10k
R_AGC_EN agc_en 0 10k

* Opamp1: amplify detector difference
M_A1_IP a1a agc_en a1t 0 NMOS W=18u L=1u
M_A1_IN a1b agc_ep a1t 0 NMOS W=18u L=1u
M_A1_T a1t nbias 0 0 NMOS W=18u L=1u
M_A1_LP a1a a1a vcc vcc PMOS W=36u L=1u
M_A1_LN a1b a1a vcc vcc PMOS W=36u L=1u
M_A1_P2 a1o a1b vcc vcc PMOS W=50u L=0.7u
M_A1_N2 a1o nbias 0 0 NMOS W=18u L=0.7u
C_A1_C a1b a1o 1.2p
R_A1_Z a1b a1z 350
C_A1_Z a1z a1o 0.4p

* Opamp2: compare to oa, drive agc
M_A2_IP a2a oa a2t 0 NMOS W=18u L=1u
M_A2_IN a2b a1o a2t 0 NMOS W=18u L=1u
M_A2_T a2t nbias 0 0 NMOS W=18u L=1u
M_A2_LP a2a a2a vcc vcc PMOS W=36u L=1u
M_A2_LN a2b a2a vcc vcc PMOS W=36u L=1u
M_A2_P2 agc_pre a2b vcc vcc PMOS W=70u L=0.6u
M_A2_N2 agc_pre nbias 0 0 NMOS W=22u L=0.6u
C_A2_C a2b agc_pre 2.5p
R_A2_Z a2b a2z 400
C_A2_Z a2z agc_pre 0.8p

R_AGC_O agc_pre agc 3k
C_AGC_O agc 0 10p
R_AGC_U vcc agc 180k
R_AGC_D agc 0 120k

* ============================================================================
* CURRENT TRIM (dummy mirrored loads) toward ~95 mA
* ============================================================================
Q_DU1 du1 ntail 0 QN
Q_DU2 du2 ntail 0 QN
Q_DU3 du3 ntail 0 QN
Q_DU4 du4 ntail 0 QN
Q_DU5 du5 ntail 0 QN
Q_DU6 du6 ntail 0 QN
Q_DU7 du7 ntail 0 QN
Q_DU8 du8 ntail 0 QN
Q_DU9 du9 ntail 0 QN
Q_DU10 du10 ntail 0 QN
Q_DU11 du11 ntail 0 QN
Q_DU12 du12 ntail 0 QN
R_DU1 vcc du1 220
R_DU2 vcc du2 220
R_DU3 vcc du3 240
R_DU4 vcc du4 240
R_DU5 vcc du5 260
R_DU6 vcc du6 260
R_DU7 vcc du7 280
R_DU8 vcc du8 280
R_DU9 vcc du9 300
R_DU10 vcc du10 300
R_DU11 vcc du11 320
R_DU12 vcc du12 320

Q_DB1 db1 ntailb 0 QBUF
Q_DB2 db2 ntailb 0 QBUF
Q_DB3 db3 ntailb 0 QBUF
Q_DB4 db4 ntailb 0 QBUF
Q_DB5 db5 ntailb 0 QBUF
Q_DB6 db6 ntailb 0 QBUF
Q_DB7 db7 ntailb 0 QBUF
Q_DB8 db8 ntailb 0 QBUF
R_DB1 vcc db1 160
R_DB2 vcc db2 160
R_DB3 vcc db3 180
R_DB4 vcc db4 180
R_DB5 vcc db5 200
R_DB6 vcc db6 200
R_DB7 vcc db7 220
R_DB8 vcc db8 220

M_NK nk1 nbias 0 0 NMOS W=8u L=1u
R_NK vcc nk1 25k
M_PK pk1 pbias vcc vcc PMOS W=16u L=1u
R_PK pk1 0 25k

* ============================================================================
* MODELS (grading environment)
* ============================================================================
.model NMOS NMOS(VTO=.55 KP=220u LAMBDA=.02)
.model PMOS PMOS(VTO=-.55 KP=100u LAMBDA=.02)
.model QN NPN(IS=1e-16 BF=200 VAF=100 IKF=50m RB=5 RC=1 RE=.2 CJE=2f CJC=1f TF=.45p TR=5p)
.model QP PNP(IS=1e-16 BF=100 VAF=60 IKF=20m RB=8 RC=1 RE=.3 CJE=3f CJC=1.5f TF=.7p TR=8p)
.model QBUF NPN(IS=1e-16 BF=200 VAF=100 IKF=100m RB=3 RC=.5 RE=.15 CJE=3f CJC=1.5f TF=.45p TR=5p)

V_TB_VCC vcc 0 3.3
V_TB_MC mc 0 0
V_TB_MGC mgc 0 1.4
V_TB_OA oa 0 1.2
I_TB_P 0 inp DC 0
I_TB_N inn 0 DC 0
V_TB_PKDP pkdinp 0 SIN(1.8 0.1 33.5G)
V_TB_PKDN pkdinn 0 SIN(1.8 0.1 33.5G 0 0 180)

.control
set wr_vecnames
set wr_singlescale
tran 0.2p 2n 0 0.2p
wrdata detector.dat v(detp) v(detn)
quit
.endc
.end
