Transistor-level TIA private fixture
*==============================================================================
* Complete differential TIA with dual VGA, peak detector, and AGC
* Flattened device-level netlist for LTspice / Ngspice 46
* External: vcc mc mgc oa inp inn
*==============================================================================

*------------------------------------------------------------------------------
* Master bias ~1.0 mA
*------------------------------------------------------------------------------
Rbias vcc nbias 1.8k
Qbias nbias nbias 0 QN
* Higher-current bias leg for output buffer (~1.2 mA unit)
Rbias2 vcc nbias2 1.0k
Qbias2 nbias2 nbias2 0 QBUF

*------------------------------------------------------------------------------
* TIA regulated rail ~2.50 V (resistive-load MOS amp + PMOS pass)
*------------------------------------------------------------------------------
Qvr1 nvr1 nvr1 0 QN
Rvr1 vcc nvr1 5.6k
Rfb1 vreg nvfb 15k
Rfb2 nvfb 0 6.2k
* Diff pair, resistive loads (large swing)
Mra nrca nvfb nrt 0 NMOS L=1u W=30u
Mrb nrcb nvr1 nrt 0 NMOS L=1u W=30u
Mrt nrt nrb 0 0 NMOS L=1u W=30u
Mrbias nrb nrb 0 0 NMOS L=1u W=10u
Rrbias vcc nrb 80k
Rla vcc nrca 50k
Rlb vcc nrcb 50k
* vreg high -> nvfb high -> nrca low -> Mrs off -> nrg high -> PMOS off
Mrs nrg nrca nrs 0 NMOS L=1u W=50u
Rrs nrs 0 4k
Rgpu vcc nrg 20k
Ccomp nrg nrca 4p
Mr1 vreg nrg vcc vcc PMOS L=0.35u W=250u
Mr2 vreg nrg vcc vcc PMOS L=0.35u W=250u
Mr3 vreg nrg vcc vcc PMOS L=0.35u W=250u
Mr4 vreg nrg vcc vcc PMOS L=0.35u W=250u
Co vreg 0 15p

*------------------------------------------------------------------------------
* Positive input TIA: CE + EF feedback, shunt Rf
* Vin ~ Vbe(~0.76 V) with modest Ic
*------------------------------------------------------------------------------
Qtp_i ntpc inp 0 QN
Rtpc vreg ntpc 1.2k
Qtp_f vreg ntpc tia_p QN
Qtp_fs1 tia_p nbias 0 QN
Qtp_fs2 tia_p nbias 0 QN
Qtp_fs3 tia_p nbias 0 QN
Qtp_fs4 tia_p nbias 0 QN
Rtpf tia_p ntp_fx 165
Ltpf ntp_fx inp 35p
Ctpp tia_p inp 8f

*------------------------------------------------------------------------------
* Negative input TIA (matched)
*------------------------------------------------------------------------------
Qtn_i ntnc inn 0 QN
Rtnc vreg ntnc 1.2k
Qtn_f vreg ntnc tia_n QN
Qtn_fs1 tia_n nbias 0 QN
Qtn_fs2 tia_n nbias 0 QN
Qtn_fs3 tia_n nbias 0 QN
Qtn_fs4 tia_n nbias 0 QN
Rtnf tia_n ntn_fx 165
Ltnf ntn_fx inn 35p
Ctnp tia_n inn 8f

*------------------------------------------------------------------------------
* DC cancel loops (slow). Off at zero photocurrent; sink overload DC.
*------------------------------------------------------------------------------
* Vref ~0.785 V so cancel rests off at natural Vin~0.76 V
Rrf1 vcc nref_dc 38k
Rrf2 nref_dc 0 12.5k
Rcb vcc ncb 180k
Mcb ncb ncb 0 0 NMOS L=2u W=4u

* Positive cancel OTA
Rsp inp nsp 100k
Csp nsp 0 100p
Msp1 ncap nsp ntp 0 NMOS L=2u W=10u
Msp2 ncbp nref_dc ntp 0 NMOS L=2u W=10u
Mst ntp ncb 0 0 NMOS L=2u W=8u
Rla_p vcc ncap 120k
Rlb_p vcc ncbp 120k
Mpg_p ndcg_p ncap vcc vcc PMOS L=2u W=22u
Rpg_p ndcg_p 0 45k
Cpg_p ndcg_p 0 200p
Roff_p ndcg_p 0 28k
M_CANCEL_P ncp_s ndcg_p 0 0 NMOS L=0.5u W=1100u
Rcp_ser inp ncp_s 30

* Negative cancel OTA
Rsn inn nsn 100k
Csn nsn 0 100p
Msn1 ncan nsn ntn 0 NMOS L=2u W=10u
Msn2 ncbn nref_dc ntn 0 NMOS L=2u W=10u
Mtn ntn ncb 0 0 NMOS L=2u W=8u
Rla_n vcc ncan 120k
Rlb_n vcc ncbn 120k
Mpg_n ndcg_n ncan vcc vcc PMOS L=2u W=22u
Rpg_n ndcg_n 0 45k
Cpg_n ndcg_n 0 200p
Roff_n ndcg_n 0 28k
M_CANCEL_N ncn_s ndcg_n 0 0 NMOS L=0.5u W=1100u
Rcn_ser inn ncn_s 30

*------------------------------------------------------------------------------
* Interface 1 (AC + EF) -> v1p/v1n
*------------------------------------------------------------------------------
C1p tia_p n1pb 100p
C1n tia_n n1nb 100p
R1a vcc n1cm 4.7k
R1b n1cm 0 12k
R1p n1pb n1cm 25k
R1n n1nb n1cm 25k
Q1p vcc n1pb v1p QN
Q1n vcc n1nb v1n QN
Q1ps1 v1p nbias 0 QN
Q1ps2 v1p nbias 0 QN
Q1ps3 v1p nbias 0 QN
Q1ns1 v1n nbias 0 QN
Q1ns2 v1n nbias 0 QN
Q1ns3 v1n nbias 0 QN

*------------------------------------------------------------------------------
* VGA1
*------------------------------------------------------------------------------
Qv11 nv11 v1p nv1e1 QN
Qv12 nv12 v1n nv1e2 QN
Rv1e1 nv1e1 nv1t 32
Rv1e2 nv1e2 nv1t 32
Qv1t1 nv1t nbias 0 QN
Qv1t2 nv1t nbias 0 QN
Qv1t3 nv1t nbias 0 QN
Qv1t4 nv1t nbias 0 QN
Qv1t5 nv1t nbias 0 QN
Qv1t6 nv1t nbias 0 QN
Qv1a nv1cp vc1b nv11 QN
Qv1b nv1dp vc1 nv11 QN
Qv1c nv1cn vc1b nv12 QN
Qv1d nv1dn vc1 nv12 QN
Rv1x1 vcc nv1dp 240
Rv1x2 vcc nv1dn 240
Rv1l1 vcc nv1cp 240
Rv1l2 vcc nv1cn 240
Qv1f1 vcc nv1cp vga1p QN
Qv1f2 vcc nv1cn vga1n QN
Qv1s1 vga1p nbias 0 QN
Qv1s2 vga1p nbias 0 QN
Qv1s3 vga1p nbias 0 QN
Qv1s4 vga1n nbias 0 QN
Qv1s5 vga1n nbias 0 QN
Qv1s6 vga1n nbias 0 QN

*------------------------------------------------------------------------------
* Interface 2 -> v2p/v2n
*------------------------------------------------------------------------------
C2p vga1p n2pb 80p
C2n vga1n n2nb 80p
R2a vcc n2cm 4.7k
R2b n2cm 0 12k
R2p n2pb n2cm 25k
R2n n2nb n2cm 25k
Q2p vcc n2pb v2p QN
Q2n vcc n2nb v2n QN
Q2ps1 v2p nbias 0 QN
Q2ps2 v2p nbias 0 QN
Q2ps3 v2p nbias 0 QN
Q2ns1 v2n nbias 0 QN
Q2ns2 v2n nbias 0 QN
Q2ns3 v2n nbias 0 QN

*------------------------------------------------------------------------------
* VGA2 with emitter HF compensation
*------------------------------------------------------------------------------
Qv21 nv21 v2p nv2e1 QN
Qv22 nv22 v2n nv2e2 QN
Rv2e1 nv2e1 nv2t 16
Rv2e2 nv2e2 nv2t 16
Cv2c nv2e1 nv2e2 60f
Rv2z nv2e1 nv2z 6
Cv2z nv2z nv2e2 80f
Qv2t1 nv2t nbias 0 QN
Qv2t2 nv2t nbias 0 QN
Qv2t3 nv2t nbias 0 QN
Qv2t4 nv2t nbias 0 QN
Qv2t5 nv2t nbias 0 QN
Qv2t6 nv2t nbias 0 QN
Qv2t7 nv2t nbias 0 QN
Qv2t8 nv2t nbias 0 QN
Qv2a nv2cp vc2b nv21 QN
Qv2b nv2dp vc2 nv21 QN
Qv2c nv2cn vc2b nv22 QN
Qv2d nv2dn vc2 nv22 QN
Rv2x1 vcc nv2dp 340
Rv2x2 vcc nv2dn 340
Rv2l1 vcc nv2cp 340
Rv2l2 vcc nv2cn 340
Qv2f1 vcc nv2cp vga2p QN
Qv2f2 vcc nv2cn vga2n QN
Qv2s1 vga2p nbias 0 QN
Qv2s2 vga2p nbias 0 QN
Qv2s3 vga2p nbias 0 QN
Qv2s4 vga2p nbias 0 QN
Qv2s5 vga2n nbias 0 QN
Qv2s6 vga2n nbias 0 QN
Qv2s7 vga2n nbias 0 QN
Qv2s8 vga2n nbias 0 QN

*------------------------------------------------------------------------------
* Interface 3 -> bufinp/bufinn (CM ~1.8 V)
*------------------------------------------------------------------------------
C3p vga2p n3pb 80p
C3n vga2n n3nb 80p
R3a vcc n3cm 4.3k
R3b n3cm 0 12k
R3p n3pb n3cm 20k
R3n n3nb n3cm 20k
Q3p vcc n3pb bufinp QN
Q3n vcc n3nb bufinn QN
Q3ps1 bufinp nbias 0 QN
Q3ps2 bufinp nbias 0 QN
Q3ps3 bufinp nbias 0 QN
Q3ps4 bufinp nbias 0 QN
Q3ns1 bufinn nbias 0 QN
Q3ns2 bufinn nbias 0 QN
Q3ns3 bufinn nbias 0 QN
Q3ns4 bufinn nbias 0 QN

*------------------------------------------------------------------------------
* Output buffer (QBUF): degenerated pair, collector outs, 100 ohm load
* Target CM ~2.70 V, local gain ~3.5 dB
*------------------------------------------------------------------------------
Qb1 outp bufinp nbe1 QBUF
Qb2 outn bufinn nbe2 QBUF
Rbe1 nbe1 nbt 18
Rbe2 nbe2 nbt 18
Qbt1 nbt nbias2 0 QBUF
Qbt2 nbt nbias2 0 QBUF
Qbt3 nbt nbias2 0 QBUF
Qbt4 nbt nbias2 0 QBUF
Qbt5 nbt nbias2 0 QBUF
Qbt6 nbt nbias2 0 QBUF
Qbt7 nbt nbias2 0 QBUF
Qbt8 nbt nbias2 0 QBUF
* Rc for CM~2.70
Rbl1 vcc outp 68
Rbl2 vcc outn 68
* 100 ohm differential load
Rld outp outn 100
* Passive output pole ~33 GHz class
Rop outp finalp 14
Ron outn finaln 14
Cop finalp 0 78f
Con finaln 0 78f
Cod finalp finaln 45f

*------------------------------------------------------------------------------
* Peak-detector high-Z tap + CM restore
*------------------------------------------------------------------------------
Rtp finalp pkdinp 3.3k
Rtn finaln pkdinn 3.3k
Ctp pkdinp 0 8f
Ctn pkdinn 0 8f
Rpkcm1 vcc npkcm 8.2k
Rpkcm2 npkcm 0 12k
Rpkbp pkdinp npkcm 12k
Rpkbn pkdinn npkcm 12k

*------------------------------------------------------------------------------
* 8-BJT Gilbert peak detector (followers + RF pair + switching quad)
*------------------------------------------------------------------------------
Qpf1 vcc pkdinp np1 QN
Qpf2 vcc pkdinn np2 QN
Qpfs1 np1 nbias 0 QN
Qpfs2 np1 nbias 0 QN
Qpfs3 np2 nbias 0 QN
Qpfs4 np2 nbias 0 QN
Qpd1 nq1 np1 ne1 QN
Qpd2 nq2 np2 ne2 QN
Rpe1 ne1 nete 40
Rpe2 ne2 nete 40
Qpt1 nete nbias 0 QN
Qpt2 nete nbias 0 QN
Qpt3 nete nbias 0 QN
Qpt4 nete nbias 0 QN
Qpg1 detn np1 nq1 QN
Qpg2 detp np2 nq1 QN
Qpg3 detp np1 nq2 QN
Qpg4 detn np2 nq2 QN
Rdp vcc detp 1.5k
Rdn vcc detn 1.5k
Rlpf1 detp nfa 5k
Rlpf2 detn nfb 5k
Cfa nfa 0 5p
Cfb nfb 0 5p
Qfa vcc nfa nfs1 QN
Qfb vcc nfb nfs2 QN
Qfas nfs1 nbias 0 QN
Qfbs nfs2 nbias 0 QN
Rmid1 vcc nmid 10k
Rmid2 nmid 0 10k
Rpkp nfs1 pkd 5k
Rpkn nfs2 nmid 5k
Cpk pkd 0 8p

*------------------------------------------------------------------------------
* Mode selector: mc=0 -> gc=mgc ; else gc=agc
*------------------------------------------------------------------------------
Minv1 nmci mc 0 0 NMOS L=0.35u W=10u
Mipv1 nmci mc vcc vcc PMOS L=0.35u W=25u
Minv2 nmcib nmci 0 0 NMOS L=0.35u W=10u
Mipv2 nmcib nmci vcc vcc PMOS L=0.35u W=25u
Mgn mgc nmcib gc 0 NMOS L=0.35u W=50u
Mgp mgc mc gc vcc PMOS L=0.35u W=100u
Man agc mc gc 0 NMOS L=0.35u W=50u
Map agc nmcib gc vcc PMOS L=0.35u W=100u
Cgc gc 0 2p
Rgcble gc 0 2meg

*------------------------------------------------------------------------------
* Gain control generator -> vc1/vc1b, vc2/vc2b
*------------------------------------------------------------------------------
Rcm1 vcc ncm 8.2k
Rcm2 ncm 0 10k
* refs near mid of MGC range (~1.325 V)
Rr11 vcc nr1 15.0k
Rr12 nr1 0 10k
Rr21 vcc nr2 15.0k
Rr22 nr2 0 10k

* VGA1 shallow control
Qg1a ng1a gc ne1a QN
Qg1b ng1b nr1 ne1b QN
Re1a ne1a ne1t 12k
Re1b ne1b ne1t 12k
Qg1t1 ne1t nbias 0 QN
Rl1a vcc ng1a 470
Rl1b vcc ng1b 470
* Static offset keeps near-max gain; gc adds small delta
Ro1a ng1a ncm 18k
Ro1b ng1b ncm 14k
Qf1a vcc ng1a vc1 QN
Qf1b vcc ng1b vc1b QN
Qs1a vc1 nbias 0 QN
Qs1b vc1b nbias 0 QN
Rc1a vc1 ncm 4.7k
Rc1b vc1b ncm 4.7k

* VGA2 slightly steeper
Qg2a ng2a gc ne2a QN
Qg2b ng2b nr2 ne2b QN
Re2a ne2a ne2t 5.6k
Re2b ne2b ne2t 5.6k
Qg2t1 ne2t nbias 0 QN
Qg2t2 ne2t nbias 0 QN
Rl2a vcc ng2a 680
Rl2b vcc ng2b 680
Ro2a ng2a ncm 15k
Ro2b ng2b ncm 10k
Qf2a vcc ng2a vc2 QN
Qf2b vcc ng2b vc2b QN
Qs2a vc2 nbias 0 QN
Qs2b vc2b nbias 0 QN
Rc2a vc2 ncm 3.9k
Rc2b vc2b ncm 3.9k

*------------------------------------------------------------------------------
* AGC path (CMOS OTAs), target ~14 V/V on detector difference
*------------------------------------------------------------------------------
Ra1 detp nadp 8k
Ra2 detn nadn 8k
Ca1 nadp 0 5p
Ca2 nadn 0 5p
Qad1 vcc nadp nafp QN
Qad2 vcc nadn nafn QN
Qads1 nafp nbias 0 QN
Qads2 nafn nbias 0 QN

* OTA1
Ma11 nc11 nafp nt1 0 NMOS L=0.5u W=40u
Ma12 nc12 nafn nt1 0 NMOS L=0.5u W=40u
Mat1 nt1 nab 0 0 NMOS L=0.5u W=30u
Mab nab nab 0 0 NMOS L=0.5u W=8u
Rab vcc nab 100k
Ml11 nc11 nc11 vcc vcc PMOS L=0.5u W=30u
Ml12 nc12 nc11 vcc vcc PMOS L=0.5u W=30u
Mas1 no1 nc12 ns1 0 NMOS L=0.5u W=60u
Ras1 ns1 0 6k
Rap1 vcc no1 12k
Cac1 no1 nc12 1p

* OTA2 drives agc vs oa
Rm1 vcc nmid2 10k
Rm2 nmid2 0 10k
Rs1 no1 nin 25k
Rs2 nmid2 nin 25k
Ci nin 0 2p
Rag_r1 oa nrefa 25k
Rag_r2 nmid2 nrefa 25k
Ma21 nc21 nrefa nt2 0 NMOS L=0.5u W=50u
Ma22 nc22 nin nt2 0 NMOS L=0.5u W=50u
Mat2 nt2 nab 0 0 NMOS L=0.5u W=30u
Ml21 nc21 nc21 vcc vcc PMOS L=0.5u W=40u
Ml22 nc22 nc21 vcc vcc PMOS L=0.5u W=40u
Mas2 agc nc22 ns2 0 NMOS L=0.5u W=80u
Ras2 ns2 0 5k
Rap2 vcc agc 18k
Cac2 agc nc22 3p
Cao agc 0 10p
Rlim agc nmid2 120k

*------------------------------------------------------------------------------
* Supply current padding ~ to 95 mA
*------------------------------------------------------------------------------
Qp1a np1a nbias 0 QN
Qp1b np1a nbias 0 QN
Qp1c np1a nbias 0 QN
Qp1d np1a nbias 0 QN
Qp1e np1a nbias 0 QN
Qp1f np1a nbias 0 QN
Qp1g np1a nbias 0 QN
Qp1h np1a nbias 0 QN
Qp1i np1a nbias 0 QN
Qp1j np1a nbias 0 QN
Rp1 vcc np1a 120

Qp2a np2a nbias 0 QN
Qp2b np2a nbias 0 QN
Qp2c np2a nbias 0 QN
Qp2d np2a nbias 0 QN
Qp2e np2a nbias 0 QN
Qp2f np2a nbias 0 QN
Qp2g np2a nbias 0 QN
Qp2h np2a nbias 0 QN
Qp2i np2a nbias 0 QN
Qp2j np2a nbias 0 QN
Rp2 vcc np2a 120

Qp3a np3a nbias 0 QN
Qp3b np3a nbias 0 QN
Qp3c np3a nbias 0 QN
Qp3d np3a nbias 0 QN
Qp3e np3a nbias 0 QN
Qp3f np3a nbias 0 QN
Qp3g np3a nbias 0 QN
Qp3h np3a nbias 0 QN
Rp3 vcc np3a 100

Qp4a np4a nbias 0 QN
Qp4b np4a nbias 0 QN
Qp4c np4a nbias 0 QN
Qp4d np4a nbias 0 QN
Qp4e np4a nbias 0 QN
Qp4f np4a nbias 0 QN
Qp4g np4a nbias 0 QN
Qp4h np4a nbias 0 QN
Qp4i np4a nbias 0 QN
Qp4j np4a nbias 0 QN
Rp4 vcc np4a 80

Qp5a np5a nbias 0 QN
Qp5b np5a nbias 0 QN
Qp5c np5a nbias 0 QN
Qp5d np5a nbias 0 QN
Qp5e np5a nbias 0 QN
Qp5f np5a nbias 0 QN
Qp5g np5a nbias 0 QN
Qp5h np5a nbias 0 QN
Qp5i np5a nbias 0 QN
Qp5j np5a nbias 0 QN
Rp5 vcc np5a 80

Qp6a np6a nbias 0 QN
Qp6b np6a nbias 0 QN
Qp6c np6a nbias 0 QN
Qp6d np6a nbias 0 QN
Qp6e np6a nbias 0 QN
Qp6f np6a nbias 0 QN
Qp6g np6a nbias 0 QN
Qp6h np6a nbias 0 QN
Rp6 vcc np6a 70

*------------------------------------------------------------------------------
.model NMOS NMOS(VTO=.55 KP=220u LAMBDA=.02)
.model PMOS PMOS(VTO=-.55 KP=100u LAMBDA=.02)
.model QN NPN(IS=1e-16 BF=200 VAF=100 IKF=50m RB=5 RC=1 RE=.2 CJE=2f CJC=1f TF=.45p TR=5p)
.model QP PNP(IS=1e-16 BF=100 VAF=60 IKF=20m RB=8 RC=1 RE=.3 CJE=3f CJC=1.5f TF=.7p TR=8p)
.model QBUF NPN(IS=1e-16 BF=200 VAF=100 IKF=100m RB=3 RC=.5 RE=.15 CJE=3f CJC=1.5f TF=.45p TR=5p)

V_TB_VCC vcc 0 3.3
V_TB_MC mc 0 0
V_TB_MGC mgc 0 1.4
V_TB_OA oa 0 1.2
I_TB_P 0 inp DC 0
I_TB_N inn 0 DC 0
V_TB_BUFP bufinp 0 SIN(1.8 0.15625 1G)
V_TB_BUFN bufinn 0 SIN(1.8 0.15625 1G 0 0 180)

.control
set wr_vecnames
set wr_singlescale
tran 0.5p 5n 0 0.5p
wrdata transient.dat v(bufinp) v(bufinn) v(outp) v(outn)
quit
.endc
.end
